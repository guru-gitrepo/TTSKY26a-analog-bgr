* NGSPICE file created from bgr_core.ext - technology: sky130A

.subckt bgr_core VDPWR VGND ua[0]
X0 RL_lay_0.R3.R1 RL_lay_0.R4.R2 VGND.t16 sky130_fd_pr__res_xhigh_po_0p35 l=4.18
X1 VDPWR.t11 M1.G0 M1.S1 VDPWR.t10 sky130_fd_pr__pfet_01v8_lvt ad=1.45 pd=10.58 as=0.725 ps=5.29 w=5 l=3
X2 M1.G0 M1.S1 RCTAT_lay_0.A VGND.t10 sky130_fd_pr__nfet_01v8_lvt ad=0.725 pd=5.29 as=0.725 ps=5.29 w=5 l=3
X3 M1.S1 M1.G0 VDPWR.t5 VDPWR.t4 sky130_fd_pr__pfet_01v8_lvt ad=0.725 pd=5.29 as=0.725 ps=5.29 w=5 l=3
X4 VGND.t20 VGND.t21 VGND.t19 sky130_fd_pr__res_xhigh_po_0p35 l=3.2
X5 VGND.t34 VGND.t36 RPTAT_lay_0.B sky130_fd_pr__pnp_05v5_W3p40L3p40
**devattr s=462400,2720 d=49018130,56065
X6 M1.S1 M1.G0 VDPWR.t1 VDPWR.t0 sky130_fd_pr__pfet_01v8_lvt ad=0.725 pd=5.29 as=1.45 ps=10.58 w=5 l=3
X7 M1.G0 M1.S1 RCTAT_lay_0.A VGND.t8 sky130_fd_pr__nfet_01v8_lvt ad=0.725 pd=5.29 as=0.725 ps=5.29 w=5 l=3
X8 RL_lay_0.R3.R1 RL_lay_0.sky130_fd_pr__res_xhigh_po_0p35_RTNBCE_0.R2 VGND.t17 sky130_fd_pr__res_xhigh_po_0p35 l=4.18
X9 RCTAT_lay_0.A RCTAT_lay_0.sky130_fd_pr__res_xhigh_po_0p35_7LQ4N7_1.R2 VGND.t24 sky130_fd_pr__res_xhigh_po_0p35 l=4.08
X10 VDPWR.t15 M1.G0 M1.G0 VDPWR.t14 sky130_fd_pr__pfet_01v8_lvt ad=0.725 pd=5.29 as=0.725 ps=5.29 w=5 l=3
X11 VGND.t32 VGND.t31 Q1.Emitter sky130_fd_pr__pnp_05v5_W3p40L3p40
**devattr s=462400,2720 d=49018130,56065
X12 RCTAT_lay_0.sky130_fd_pr__res_xhigh_po_0p35_7LQ4N7_2.R1 RCTAT_lay_0.sky130_fd_pr__res_xhigh_po_0p35_7LQ4N7_3.R2 VGND.t22 sky130_fd_pr__res_xhigh_po_0p35 l=4.08
X13 VGND.t39 VGND.t38 RPTAT_lay_0.B sky130_fd_pr__pnp_05v5_W3p40L3p40
**devattr s=462400,2720 d=49018130,56065
X14 VGND.t41 VGND.t40 RPTAT_lay_0.B sky130_fd_pr__pnp_05v5_W3p40L3p40
**devattr s=462400,2720 d=49018130,56065
X15 VDPWR.t19 M1.G0 M1.G0 VDPWR.t18 sky130_fd_pr__pfet_01v8_lvt ad=0.725 pd=5.29 as=0.725 ps=5.29 w=5 l=3
X16 Q1.Emitter M1.S1 M1.S1 VGND.t5 sky130_fd_pr__nfet_01v8_lvt ad=1.45 pd=10.58 as=0.725 ps=5.29 w=5 l=3
X17 RCTAT_lay_0.A M1.S1 M1.G0 VGND.t11 sky130_fd_pr__nfet_01v8_lvt ad=1.45 pd=10.58 as=0.725 ps=5.29 w=5 l=3
X18 ua[0].t6 RL_lay_0.sky130_fd_pr__res_xhigh_po_0p35_RTNBCE_0.R2 VGND.t18 sky130_fd_pr__res_xhigh_po_0p35 l=4.18
X19 RCTAT_lay_0.sky130_fd_pr__res_xhigh_po_0p35_7LQ4N7_4.R1 RCTAT_lay_0.sky130_fd_pr__res_xhigh_po_0p35_7LQ4N7_5.R2 VGND.t28 sky130_fd_pr__res_xhigh_po_0p35 l=4.08
X20 VDPWR.t3 M1.G0 M1.S1 VDPWR.t2 sky130_fd_pr__pfet_01v8_lvt ad=0.725 pd=5.29 as=0.725 ps=5.29 w=5 l=3
X21 M1.S1 M1.S1 Q1.Emitter VGND.t2 sky130_fd_pr__nfet_01v8_lvt ad=0.725 pd=5.29 as=0.725 ps=5.29 w=5 l=3
X22 RCTAT_lay_0.A M1.S1 M1.G0 VGND.t7 sky130_fd_pr__nfet_01v8_lvt ad=0.725 pd=5.29 as=0.725 ps=5.29 w=5 l=3
X23 VGND.t34 VGND.t33 RPTAT_lay_0.B sky130_fd_pr__pnp_05v5_W3p40L3p40
**devattr s=462400,2720 d=49018130,56065
X24 M1.S1 M1.S1 Q1.Emitter VGND.t0 sky130_fd_pr__nfet_01v8_lvt ad=0.725 pd=5.29 as=1.45 ps=10.58 w=5 l=3
X25 VGND.t45 VGND.t46 VGND.t44 sky130_fd_pr__res_xhigh_po_0p35 l=3.2
X26 VGND.t41 VGND.t42 RPTAT_lay_0.B sky130_fd_pr__pnp_05v5_W3p40L3p40
**devattr s=462400,2720 d=49018130,56065
X27 ua[0].t1 M1.G0 VDPWR.t25 VDPWR.t24 sky130_fd_pr__pfet_01v8_lvt ad=0.725 pd=5.29 as=1.45 ps=10.58 w=5 l=3
X28 MSU1.S M1.S1 VGND.t13 VGND.t12 sky130_fd_pr__nfet_01v8 ad=0.29 pd=2.58 as=0.29 ps=2.58 w=1 l=2
X29 M1.G0 MSU2.S M1.S1 VGND.t25 sky130_fd_pr__nfet_01v8 ad=0.145 pd=1.58 as=0.145 ps=1.58 w=0.5 l=0.15
X30 VGND.t34 VGND.t35 RPTAT_lay_0.B sky130_fd_pr__pnp_05v5_W3p40L3p40
**devattr s=462400,2720 d=49018130,56065
X31 MSU2.S MSU2.S VDPWR.t38 VDPWR.t37 sky130_fd_pr__pfet_01v8 ad=0.29 pd=2.58 as=0.29 ps=2.58 w=1 l=2
X32 ua[0].t3 M1.G0 VDPWR.t33 VDPWR.t32 sky130_fd_pr__pfet_01v8_lvt ad=0.725 pd=5.29 as=0.725 ps=5.29 w=5 l=3
X33 VDPWR.t35 M1.G0 ua[0].t0 VDPWR.t34 sky130_fd_pr__pfet_01v8_lvt ad=1.45 pd=10.58 as=0.725 ps=5.29 w=5 l=3
X34 M1.G0 M1.G0 VDPWR.t13 VDPWR.t12 sky130_fd_pr__pfet_01v8_lvt ad=0.725 pd=5.29 as=1.45 ps=10.58 w=5 l=3
X35 RCTAT_lay_0.sky130_fd_pr__res_xhigh_po_0p35_7LQ4N7_2.R1 RCTAT_lay_0.sky130_fd_pr__res_xhigh_po_0p35_7LQ4N7_1.R2 VGND.t23 sky130_fd_pr__res_xhigh_po_0p35 l=4.08
X36 VGND.t32 VGND.t37 RPTAT_lay_0.B sky130_fd_pr__pnp_05v5_W3p40L3p40
**devattr s=462400,2720 d=49018130,56065
X37 Q1.Emitter M1.S1 M1.S1 VGND.t1 sky130_fd_pr__nfet_01v8_lvt ad=0.725 pd=5.29 as=0.725 ps=5.29 w=5 l=3
X38 VDPWR.t7 M1.G0 M1.S1 VDPWR.t6 sky130_fd_pr__pfet_01v8_lvt ad=0.725 pd=5.29 as=0.725 ps=5.29 w=5 l=3
X39 M1.S1 M1.G0 VDPWR.t9 VDPWR.t8 sky130_fd_pr__pfet_01v8_lvt ad=0.725 pd=5.29 as=0.725 ps=5.29 w=5 l=3
X40 RCTAT_lay_0.A M1.S1 M1.G0 VGND.t9 sky130_fd_pr__nfet_01v8_lvt ad=0.725 pd=5.29 as=0.725 ps=5.29 w=5 l=3
X41 RCTAT_lay_0.A RPTAT_lay_0.B VGND.t27 sky130_fd_pr__res_xhigh_po_0p35 l=3.2
X42 M1.G0 M1.S1 RCTAT_lay_0.A VGND.t6 sky130_fd_pr__nfet_01v8_lvt ad=0.725 pd=5.29 as=1.45 ps=10.58 w=5 l=3
X43 VDPWR.t27 M1.G0 ua[0].t5 VDPWR.t26 sky130_fd_pr__pfet_01v8_lvt ad=0.725 pd=5.29 as=0.725 ps=5.29 w=5 l=3
X44 ua[0].t2 M1.G0 VDPWR.t29 VDPWR.t28 sky130_fd_pr__pfet_01v8_lvt ad=0.725 pd=5.29 as=0.725 ps=5.29 w=5 l=3
X45 MSU1.S MSU1.S MSU2.S VDPWR.t36 sky130_fd_pr__pfet_01v8 ad=0.29 pd=2.58 as=0.29 ps=2.58 w=1 l=2
X46 VGND.t15 RL_lay_0.R4.R2 VGND.t14 sky130_fd_pr__res_xhigh_po_0p35 l=4.18
X47 M1.G0 M1.G0 VDPWR.t21 VDPWR.t20 sky130_fd_pr__pfet_01v8_lvt ad=0.725 pd=5.29 as=0.725 ps=5.29 w=5 l=3
X48 VDPWR.t23 M1.G0 M1.G0 VDPWR.t22 sky130_fd_pr__pfet_01v8_lvt ad=1.45 pd=10.58 as=0.725 ps=5.29 w=5 l=3
X49 RCTAT_lay_0.sky130_fd_pr__res_xhigh_po_0p35_7LQ4N7_4.R1 RCTAT_lay_0.sky130_fd_pr__res_xhigh_po_0p35_7LQ4N7_3.R2 VGND.t26 sky130_fd_pr__res_xhigh_po_0p35 l=4.08
X50 M1.G0 M1.G0 VDPWR.t17 VDPWR.t16 sky130_fd_pr__pfet_01v8_lvt ad=0.725 pd=5.29 as=0.725 ps=5.29 w=5 l=3
X51 VDPWR.t31 M1.G0 ua[0].t4 VDPWR.t30 sky130_fd_pr__pfet_01v8_lvt ad=0.725 pd=5.29 as=0.725 ps=5.29 w=5 l=3
X52 Q1.Emitter M1.S1 M1.S1 VGND.t3 sky130_fd_pr__nfet_01v8_lvt ad=0.725 pd=5.29 as=0.725 ps=5.29 w=5 l=3
X53 M1.S1 M1.S1 Q1.Emitter VGND.t4 sky130_fd_pr__nfet_01v8_lvt ad=0.725 pd=5.29 as=0.725 ps=5.29 w=5 l=3
X54 VGND.t30 RCTAT_lay_0.sky130_fd_pr__res_xhigh_po_0p35_7LQ4N7_5.R2 VGND.t29 sky130_fd_pr__res_xhigh_po_0p35 l=4.08
X55 VGND.t41 VGND.t43 RPTAT_lay_0.B sky130_fd_pr__pnp_05v5_W3p40L3p40
**devattr s=462400,2720 d=49018130,56065
R0 ua[0].n51 ua[0].n50 585
R1 ua[0].n51 ua[0].n6 585
R2 ua[0].n51 ua[0].n5 585
R3 ua[0].n51 ua[0] 585
R4 ua[0].n51 ua[0].n4 585
R5 ua[0].n51 ua[0].n3 585
R6 ua[0].n52 ua[0].n51 585
R7 ua[0].n27 ua[0].n23 585
R8 ua[0].n27 ua[0] 585
R9 ua[0].n28 ua[0].n27 585
R10 ua[0].n27 ua[0].n26 289.262
R11 ua[0].n27 ua[0].n21 289.26
R12 ua[0].n16 ua[0].n13 192.279
R13 ua[0].n14 ua[0].n13 144.278
R14 ua[0].n56 ua[0].t6 40.8142
R15 ua[0].n56 ua[0] 33.275
R16 ua[0].n53 ua[0].n52 25.4862
R17 ua[0].n50 ua[0].n7 25.4709
R18 ua[0].n16 ua[0].n15 24.5584
R19 ua[0].n21 ua[0].n20 19.6002
R20 ua[0].n26 ua[0].n25 19.5986
R21 ua[0].n49 ua[0].n6 16.5652
R22 ua[0].n3 ua[0].n2 16.5652
R23 ua[0].n8 ua[0].n5 15.0593
R24 ua[0].n36 ua[0].n4 15.0593
R25 ua[0].n25 ua[0].n23 15.0593
R26 ua[0].n28 ua[0].n20 15.0593
R27 ua[0].n26 ua[0].n10 14.6037
R28 ua[0].n21 ua[0].n11 14.5505
R29 ua[0] ua[0].n14 13.7368
R30 ua[0].n42 ua[0] 13.5534
R31 ua[0].n38 ua[0] 13.5534
R32 ua[0].n15 ua[0] 13.5534
R33 ua[0].n22 ua[0] 13.5534
R34 ua[0].n29 ua[0] 13.5534
R35 ua[0].n42 ua[0].n5 12.0476
R36 ua[0].n38 ua[0].n4 12.0476
R37 ua[0].n23 ua[0].n22 12.0476
R38 ua[0].n29 ua[0].n28 12.0476
R39 ua[0].n8 ua[0].n6 10.5417
R40 ua[0].n36 ua[0].n3 10.5417
R41 ua[0].n17 ua[0].n16 9.51453
R42 ua[0].n2 ua[0].n1 9.3005
R43 ua[0].n37 ua[0].n36 9.3005
R44 ua[0].n39 ua[0].n38 9.3005
R45 ua[0].n49 ua[0].n48 9.3005
R46 ua[0].n9 ua[0].n8 9.3005
R47 ua[0].n43 ua[0].n42 9.3005
R48 ua[0].n15 ua[0].n12 9.3005
R49 ua[0].n20 ua[0].n19 9.3005
R50 ua[0].n30 ua[0].n29 9.3005
R51 ua[0].n25 ua[0].n24 9.3005
R52 ua[0].n22 ua[0].n18 9.3005
R53 ua[0].n50 ua[0].n49 9.03579
R54 ua[0].n52 ua[0].n2 9.03579
R55 ua[0].n14 ua[0].n12 6.74741
R56 ua[0].n51 ua[0].t0 5.7135
R57 ua[0].n51 ua[0].t3 5.7135
R58 ua[0].n13 ua[0].t5 5.7135
R59 ua[0].n13 ua[0].t1 5.7135
R60 ua[0].n27 ua[0].t4 5.7135
R61 ua[0].n27 ua[0].t2 5.7135
R62 ua[0].n46 ua[0].n7 4.53859
R63 ua[0].n32 ua[0].n31 4.5005
R64 ua[0].n47 ua[0].n46 4.5005
R65 ua[0].n45 ua[0].n44 4.5005
R66 ua[0].n35 ua[0].n0 4.5005
R67 ua[0].n54 ua[0].n53 4.5005
R68 ua[0].n32 ua[0].n17 1.69172
R69 ua[0].n57 ua[0].n56 1.55639
R70 ua[0].n34 ua[0].n33 1.30258
R71 ua[0].n41 ua[0].n40 1.1255
R72 ua[0].n57 ua[0].n55 0.947605
R73 ua[0].n55 ua[0] 0.921935
R74 ua[0].n33 ua[0].n10 0.84425
R75 ua[0].n33 ua[0].n11 0.84425
R76 ua[0].n55 ua[0].n54 0.531937
R77 ua[0] ua[0].n57 0.26425
R78 ua[0].n39 ua[0].n37 0.0647857
R79 ua[0].n24 ua[0].n18 0.0647857
R80 ua[0].n30 ua[0].n19 0.0647857
R81 ua[0].n19 ua[0].n11 0.0621071
R82 ua[0].n43 ua[0].n41 0.0585357
R83 ua[0].n40 ua[0].n0 0.0576429
R84 ua[0].n31 ua[0].n18 0.05675
R85 ua[0].n45 ua[0].n34 0.0564524
R86 ua[0].n35 ua[0].n1 0.0496071
R87 ua[0].n48 ua[0].n47 0.04425
R88 ua[0].n46 ua[0].n45 0.0385952
R89 ua[0].n54 ua[0].n0 0.0385952
R90 ua[0].n44 ua[0].n9 0.0371071
R91 ua[0].n44 ua[0].n43 0.0281786
R92 ua[0].n47 ua[0].n9 0.0210357
R93 ua[0].n37 ua[0].n35 0.0156786
R94 ua[0].n48 ua[0].n7 0.0138929
R95 ua[0].n24 ua[0].n10 0.0138929
R96 ua[0].n53 ua[0].n1 0.00853571
R97 ua[0].n31 ua[0].n30 0.00853571
R98 ua[0].n41 ua[0].n39 0.00675
R99 ua[0].n33 ua[0].n32 0.00570833
R100 ua[0].n40 ua[0].n34 0.00169048
R101 ua[0].n17 ua[0].n12 0.00139286
R102 VDPWR.n111 VDPWR.n107 9051.59
R103 VDPWR.n108 VDPWR.t36 666.939
R104 VDPWR.n108 VDPWR.t37 665
R105 VDPWR.t12 VDPWR.t10 638.889
R106 VDPWR VDPWR.t38 613.566
R107 VDPWR.n98 VDPWR.n97 585
R108 VDPWR.n97 VDPWR.n90 585
R109 VDPWR.n97 VDPWR.n96 585
R110 VDPWR.n97 VDPWR 585
R111 VDPWR.n86 VDPWR.n85 585
R112 VDPWR.n85 VDPWR.n84 585
R113 VDPWR.n85 VDPWR.n79 585
R114 VDPWR.n85 VDPWR 585
R115 VDPWR.n74 VDPWR.n73 585
R116 VDPWR.n73 VDPWR.n72 585
R117 VDPWR.n73 VDPWR.n67 585
R118 VDPWR.n73 VDPWR 585
R119 VDPWR.n62 VDPWR.n61 585
R120 VDPWR.n61 VDPWR.n54 585
R121 VDPWR.n61 VDPWR.n60 585
R122 VDPWR.n61 VDPWR 585
R123 VDPWR.n50 VDPWR.n49 585
R124 VDPWR.n49 VDPWR.n48 585
R125 VDPWR.n49 VDPWR.n43 585
R126 VDPWR.n49 VDPWR 585
R127 VDPWR.n38 VDPWR.n37 585
R128 VDPWR.n37 VDPWR.n36 585
R129 VDPWR.n37 VDPWR.n31 585
R130 VDPWR.n37 VDPWR 585
R131 VDPWR.n26 VDPWR.n25 585
R132 VDPWR.n25 VDPWR.n18 585
R133 VDPWR.n25 VDPWR.n24 585
R134 VDPWR.n25 VDPWR 585
R135 VDPWR.n14 VDPWR.n13 585
R136 VDPWR.n13 VDPWR.n12 585
R137 VDPWR.n13 VDPWR.n7 585
R138 VDPWR.n13 VDPWR 585
R139 VDPWR.n126 VDPWR.n125 585
R140 VDPWR.n126 VDPWR.n3 585
R141 VDPWR.n126 VDPWR.n2 585
R142 VDPWR VDPWR.n126 585
R143 VDPWR.t22 VDPWR.t24 551.054
R144 VDPWR.t20 VDPWR.t22 456.945
R145 VDPWR.t18 VDPWR.t20 456.945
R146 VDPWR.t16 VDPWR.t14 456.945
R147 VDPWR.t14 VDPWR.t12 456.945
R148 VDPWR.t10 VDPWR.t8 456.945
R149 VDPWR.t8 VDPWR.t6 456.945
R150 VDPWR.t6 VDPWR.t4 456.945
R151 VDPWR.t4 VDPWR.t2 456.945
R152 VDPWR.t2 VDPWR.t0 456.945
R153 VDPWR.t28 VDPWR.t30 420.943
R154 VDPWR.t24 VDPWR.t26 420.943
R155 VDPWR.t32 VDPWR.t34 411.762
R156 VDPWR.t26 VDPWR.n109 401.752
R157 VDPWR.n108 VDPWR.t32 393.435
R158 VDPWR.n112 VDPWR.n106 352.731
R159 VDPWR.n110 VDPWR.t16 229.862
R160 VDPWR.n110 VDPWR.t18 227.083
R161 VDPWR.n13 VDPWR.n6 197.698
R162 VDPWR.n126 VDPWR.n1 197.698
R163 VDPWR.n85 VDPWR.n78 197.698
R164 VDPWR.n73 VDPWR.n66 197.698
R165 VDPWR.n25 VDPWR.n19 197.698
R166 VDPWR.n97 VDPWR.n91 197.698
R167 VDPWR.n49 VDPWR.n42 197.698
R168 VDPWR.n37 VDPWR.n30 197.698
R169 VDPWR.n61 VDPWR.n55 197.698
R170 VDPWR.n118 VDPWR.t35 92.781
R171 VDPWR.n115 VDPWR.t23 92.2351
R172 VDPWR.n102 VDPWR.t11 92.2351
R173 VDPWR.n106 VDPWR 71.6216
R174 VDPWR.t30 VDPWR.n108 27.5089
R175 VDPWR.n99 VDPWR.n98 25.3691
R176 VDPWR.n87 VDPWR.n86 25.3691
R177 VDPWR.n75 VDPWR.n74 25.3691
R178 VDPWR.n63 VDPWR.n62 25.3691
R179 VDPWR.n51 VDPWR.n50 25.3691
R180 VDPWR.n39 VDPWR.n38 25.3691
R181 VDPWR.n27 VDPWR.n26 25.3691
R182 VDPWR.n15 VDPWR.n14 25.3691
R183 VDPWR.n125 VDPWR.n119 25.3691
R184 VDPWR.n107 VDPWR.n106 23.1471
R185 VDPWR.n109 VDPWR.t28 19.1924
R186 VDPWR.n55 VDPWR 18.8127
R187 VDPWR.n91 VDPWR 18.8127
R188 VDPWR VDPWR.n42 18.8127
R189 VDPWR VDPWR.n30 18.8127
R190 VDPWR VDPWR.n78 18.8127
R191 VDPWR VDPWR.n66 18.8127
R192 VDPWR.n19 VDPWR 18.8127
R193 VDPWR VDPWR.n6 18.8127
R194 VDPWR VDPWR.n1 18.8127
R195 VDPWR.n90 VDPWR.n89 16.5652
R196 VDPWR.n84 VDPWR.n77 16.5652
R197 VDPWR.n72 VDPWR.n65 16.5652
R198 VDPWR.n54 VDPWR.n53 16.5652
R199 VDPWR.n48 VDPWR.n41 16.5652
R200 VDPWR.n36 VDPWR.n29 16.5652
R201 VDPWR.n18 VDPWR.n17 16.5652
R202 VDPWR.n12 VDPWR.n5 16.5652
R203 VDPWR.n124 VDPWR.n3 16.5652
R204 VDPWR.n96 VDPWR.n92 15.0593
R205 VDPWR.n83 VDPWR.n79 15.0593
R206 VDPWR.n71 VDPWR.n67 15.0593
R207 VDPWR.n60 VDPWR.n56 15.0593
R208 VDPWR.n47 VDPWR.n43 15.0593
R209 VDPWR.n35 VDPWR.n31 15.0593
R210 VDPWR.n24 VDPWR.n20 15.0593
R211 VDPWR.n11 VDPWR.n7 15.0593
R212 VDPWR.n121 VDPWR.n2 15.0593
R213 VDPWR.n95 VDPWR 13.5534
R214 VDPWR.n80 VDPWR 13.5534
R215 VDPWR.n68 VDPWR 13.5534
R216 VDPWR.n59 VDPWR 13.5534
R217 VDPWR.n44 VDPWR 13.5534
R218 VDPWR.n32 VDPWR 13.5534
R219 VDPWR.n23 VDPWR 13.5534
R220 VDPWR.n8 VDPWR 13.5534
R221 VDPWR VDPWR.n0 13.5534
R222 VDPWR.n96 VDPWR.n95 12.0476
R223 VDPWR.n80 VDPWR.n79 12.0476
R224 VDPWR.n68 VDPWR.n67 12.0476
R225 VDPWR.n60 VDPWR.n59 12.0476
R226 VDPWR.n44 VDPWR.n43 12.0476
R227 VDPWR.n32 VDPWR.n31 12.0476
R228 VDPWR.n24 VDPWR.n23 12.0476
R229 VDPWR.n8 VDPWR.n7 12.0476
R230 VDPWR.n2 VDPWR.n0 12.0476
R231 VDPWR.n92 VDPWR.n90 10.5417
R232 VDPWR.n84 VDPWR.n83 10.5417
R233 VDPWR.n72 VDPWR.n71 10.5417
R234 VDPWR.n56 VDPWR.n54 10.5417
R235 VDPWR.n48 VDPWR.n47 10.5417
R236 VDPWR.n36 VDPWR.n35 10.5417
R237 VDPWR.n20 VDPWR.n18 10.5417
R238 VDPWR.n12 VDPWR.n11 10.5417
R239 VDPWR.n121 VDPWR.n3 10.5417
R240 VDPWR.n89 VDPWR.n88 9.3005
R241 VDPWR.n93 VDPWR.n92 9.3005
R242 VDPWR.n95 VDPWR.n94 9.3005
R243 VDPWR.n77 VDPWR.n76 9.3005
R244 VDPWR.n83 VDPWR.n82 9.3005
R245 VDPWR.n81 VDPWR.n80 9.3005
R246 VDPWR.n65 VDPWR.n64 9.3005
R247 VDPWR.n71 VDPWR.n70 9.3005
R248 VDPWR.n69 VDPWR.n68 9.3005
R249 VDPWR.n53 VDPWR.n52 9.3005
R250 VDPWR.n57 VDPWR.n56 9.3005
R251 VDPWR.n59 VDPWR.n58 9.3005
R252 VDPWR.n41 VDPWR.n40 9.3005
R253 VDPWR.n47 VDPWR.n46 9.3005
R254 VDPWR.n45 VDPWR.n44 9.3005
R255 VDPWR.n29 VDPWR.n28 9.3005
R256 VDPWR.n35 VDPWR.n34 9.3005
R257 VDPWR.n33 VDPWR.n32 9.3005
R258 VDPWR.n17 VDPWR.n16 9.3005
R259 VDPWR.n21 VDPWR.n20 9.3005
R260 VDPWR.n23 VDPWR.n22 9.3005
R261 VDPWR.n5 VDPWR.n4 9.3005
R262 VDPWR.n11 VDPWR.n10 9.3005
R263 VDPWR.n9 VDPWR.n8 9.3005
R264 VDPWR.n124 VDPWR.n123 9.3005
R265 VDPWR.n122 VDPWR.n121 9.3005
R266 VDPWR.n120 VDPWR.n0 9.3005
R267 VDPWR.n98 VDPWR.n89 9.03579
R268 VDPWR.n86 VDPWR.n77 9.03579
R269 VDPWR.n74 VDPWR.n65 9.03579
R270 VDPWR.n62 VDPWR.n53 9.03579
R271 VDPWR.n50 VDPWR.n41 9.03579
R272 VDPWR.n38 VDPWR.n29 9.03579
R273 VDPWR.n26 VDPWR.n17 9.03579
R274 VDPWR.n14 VDPWR.n5 9.03579
R275 VDPWR.n125 VDPWR.n124 9.03579
R276 VDPWR.n97 VDPWR.t1 5.7135
R277 VDPWR.n85 VDPWR.t5 5.7135
R278 VDPWR.n85 VDPWR.t3 5.7135
R279 VDPWR.n73 VDPWR.t9 5.7135
R280 VDPWR.n73 VDPWR.t7 5.7135
R281 VDPWR.n61 VDPWR.t13 5.7135
R282 VDPWR.n49 VDPWR.t17 5.7135
R283 VDPWR.n49 VDPWR.t15 5.7135
R284 VDPWR.n37 VDPWR.t21 5.7135
R285 VDPWR.n37 VDPWR.t19 5.7135
R286 VDPWR.n25 VDPWR.t25 5.7135
R287 VDPWR.n13 VDPWR.t29 5.7135
R288 VDPWR.n13 VDPWR.t27 5.7135
R289 VDPWR.n126 VDPWR.t33 5.7135
R290 VDPWR.n126 VDPWR.t31 5.7135
R291 VDPWR.n109 VDPWR.n107 4.5127
R292 VDPWR.n105 VDPWR 2.71026
R293 VDPWR.n9 VDPWR.n6 2.16295
R294 VDPWR.n120 VDPWR.n1 2.16295
R295 VDPWR.n81 VDPWR.n78 2.16293
R296 VDPWR.n69 VDPWR.n66 2.16293
R297 VDPWR.n22 VDPWR.n19 2.16293
R298 VDPWR.n94 VDPWR.n91 2.16292
R299 VDPWR.n33 VDPWR.n30 2.16292
R300 VDPWR.n45 VDPWR.n42 2.16292
R301 VDPWR.n58 VDPWR.n55 2.16292
R302 VDPWR.n100 VDPWR.n99 1.0348
R303 VDPWR.n112 VDPWR.n111 1.0005
R304 VDPWR.n111 VDPWR.n110 1.0005
R305 VDPWR.n102 VDPWR.n101 0.554667
R306 VDPWR.n118 VDPWR.n117 0.5505
R307 VDPWR.n117 VDPWR.n116 0.5505
R308 VDPWR.n115 VDPWR.n114 0.5505
R309 VDPWR.n104 VDPWR.n103 0.546333
R310 VDPWR.n101 VDPWR.n100 0.546333
R311 VDPWR.n100 VDPWR.n87 0.488969
R312 VDPWR.n101 VDPWR.n75 0.488969
R313 VDPWR.n103 VDPWR.n63 0.488969
R314 VDPWR.n104 VDPWR.n51 0.488969
R315 VDPWR.n114 VDPWR.n39 0.488969
R316 VDPWR.n116 VDPWR.n27 0.488969
R317 VDPWR.n117 VDPWR.n15 0.488969
R318 VDPWR.n119 VDPWR.n118 0.488969
R319 VDPWR.n114 VDPWR.n113 0.271333
R320 VDPWR.n105 VDPWR.n104 0.271333
R321 VDPWR.n99 VDPWR.n88 0.143564
R322 VDPWR.n87 VDPWR.n76 0.143564
R323 VDPWR.n75 VDPWR.n64 0.143564
R324 VDPWR.n63 VDPWR.n52 0.143564
R325 VDPWR.n51 VDPWR.n40 0.143564
R326 VDPWR.n39 VDPWR.n28 0.143564
R327 VDPWR.n27 VDPWR.n16 0.143564
R328 VDPWR.n15 VDPWR.n4 0.143564
R329 VDPWR.n123 VDPWR.n119 0.143564
R330 VDPWR.n93 VDPWR.n88 0.113
R331 VDPWR.n94 VDPWR.n93 0.113
R332 VDPWR.n82 VDPWR.n76 0.113
R333 VDPWR.n82 VDPWR.n81 0.113
R334 VDPWR.n70 VDPWR.n64 0.113
R335 VDPWR.n70 VDPWR.n69 0.113
R336 VDPWR.n57 VDPWR.n52 0.113
R337 VDPWR.n58 VDPWR.n57 0.113
R338 VDPWR.n46 VDPWR.n40 0.113
R339 VDPWR.n46 VDPWR.n45 0.113
R340 VDPWR.n34 VDPWR.n28 0.113
R341 VDPWR.n34 VDPWR.n33 0.113
R342 VDPWR.n21 VDPWR.n16 0.113
R343 VDPWR.n22 VDPWR.n21 0.113
R344 VDPWR.n10 VDPWR.n4 0.113
R345 VDPWR.n10 VDPWR.n9 0.113
R346 VDPWR.n123 VDPWR.n122 0.113
R347 VDPWR.n122 VDPWR.n120 0.113
R348 VDPWR.n116 VDPWR.n115 0.108833
R349 VDPWR.n103 VDPWR.n102 0.108833
R350 VDPWR.n113 VDPWR.n112 0.0272241
R351 VDPWR.n113 VDPWR.n105 0.00466667
R352 VGND.n792 VGND.n791 466973
R353 VGND.n0 VGND.t39 4.20981
R354 VGND.t32 VGND.n31 23023.1
R355 VGND.n1788 VGND.n1787 11130.5
R356 VGND.n1797 VGND.n201 10047
R357 VGND.n1980 VGND.t39 9048.66
R358 VGND.n1072 VGND.n1071 6762.67
R359 VGND.t41 VGND.n14 4531.44
R360 VGND.n204 VGND.n200 4438.73
R361 VGND.n790 VGND.n7 3709.19
R362 VGND.n1364 VGND.n1005 3242.67
R363 VGND.n1005 VGND.n356 3178.67
R364 VGND.n1364 VGND.n1006 3136
R365 VGND.n1072 VGND.n1006 3093.33
R366 VGND.n1980 VGND.t41 3008.46
R367 VGND.n498 VGND.n356 2752.62
R368 VGND.n1788 VGND.n200 2558.65
R369 VGND.n905 VGND.n498 2024.28
R370 VGND.n907 VGND.n905 1792
R371 VGND.n1980 VGND.t11 1690.65
R372 VGND.t10 VGND.t11 1573.48
R373 VGND.t9 VGND.t10 1573.48
R374 VGND.t8 VGND.t7 1573.48
R375 VGND.t7 VGND.t6 1573.48
R376 VGND.n1797 VGND.n200 1296.92
R377 VGND.t34 VGND.t8 1272.17
R378 VGND.n1660 VGND.n194 1170.95
R379 VGND.n818 VGND.n796 1007.63
R380 VGND.n818 VGND.n817 1007.63
R381 VGND.n817 VGND.n816 1007.63
R382 VGND.n816 VGND.n797 1007.63
R383 VGND.n797 VGND.n368 1007.63
R384 VGND.n806 VGND.n369 1007.63
R385 VGND.n806 VGND.n805 1007.63
R386 VGND.n805 VGND.n804 1007.63
R387 VGND.n804 VGND.n361 1007.63
R388 VGND.n1001 VGND.n361 1007.63
R389 VGND.n1370 VGND.n353 1007.63
R390 VGND.n1370 VGND.n1369 1007.63
R391 VGND.n1369 VGND.n1368 1007.63
R392 VGND.n1368 VGND.n354 1007.63
R393 VGND.n1361 VGND.n354 1007.63
R394 VGND.n1359 VGND.n1358 1007.63
R395 VGND.n1358 VGND.n1357 1007.63
R396 VGND.n1357 VGND.n1009 1007.63
R397 VGND.n1351 VGND.n1009 1007.63
R398 VGND.n1351 VGND.n1350 1007.63
R399 VGND.t12 VGND.n1980 908.487
R400 VGND.n557 VGND.n517 872.247
R401 VGND.n524 VGND.n517 872.247
R402 VGND.n550 VGND.n524 872.247
R403 VGND.n550 VGND.n549 872.247
R404 VGND.n549 VGND.n362 872.247
R405 VGND.n542 VGND.n363 872.247
R406 VGND.n542 VGND.n541 872.247
R407 VGND.n541 VGND.n540 872.247
R408 VGND.n540 VGND.n532 872.247
R409 VGND.n532 VGND.n364 872.247
R410 VGND.n773 VGND.n772 872.247
R411 VGND.n772 VGND.n771 872.247
R412 VGND.n771 VGND.n578 872.247
R413 VGND.n765 VGND.n578 872.247
R414 VGND.n765 VGND.n365 872.247
R415 VGND.n591 VGND.n366 872.247
R416 VGND.n758 VGND.n591 872.247
R417 VGND.n758 VGND.n757 872.247
R418 VGND.n757 VGND.n756 872.247
R419 VGND.n756 VGND.n367 872.247
R420 VGND.n1472 VGND.n290 868.422
R421 VGND.n1478 VGND.n290 868.422
R422 VGND.n1479 VGND.n1478 868.422
R423 VGND.n1479 VGND.n286 868.422
R424 VGND.n1485 VGND.n286 868.422
R425 VGND.n1491 VGND.n282 868.422
R426 VGND.n1492 VGND.n1491 868.422
R427 VGND.n1492 VGND.n278 868.422
R428 VGND.n1498 VGND.n278 868.422
R429 VGND.n1499 VGND.n1498 868.422
R430 VGND.n1059 VGND.n1054 814.58
R431 VGND.n1187 VGND.n1186 772.768
R432 VGND.t34 VGND.n369 682.952
R433 VGND.n1359 VGND.t32 682.952
R434 VGND.n1442 VGND.n327 629.801
R435 VGND.n1442 VGND.n326 602.707
R436 VGND.n1203 VGND.n1058 595.312
R437 VGND.t34 VGND.n363 591.189
R438 VGND.t34 VGND.n366 591.189
R439 VGND.n1780 VGND.n221 589.514
R440 VGND.n282 VGND.t32 588.596
R441 VGND.n653 VGND.n652 585
R442 VGND.n651 VGND.n620 585
R443 VGND.n647 VGND.n646 585
R444 VGND.n642 VGND.n623 585
R445 VGND.n639 VGND.n638 585
R446 VGND.n634 VGND.n627 585
R447 VGND.n631 VGND.n630 585
R448 VGND.n599 VGND.n598 585
R449 VGND.n714 VGND.n597 585
R450 VGND.n594 VGND.n294 585
R451 VGND.n653 VGND.n359 585
R452 VGND.n651 VGND.n650 585
R453 VGND.n648 VGND.n647 585
R454 VGND.n642 VGND.n641 585
R455 VGND.n640 VGND.n639 585
R456 VGND.n634 VGND.n633 585
R457 VGND.n632 VGND.n631 585
R458 VGND.n599 VGND.n595 585
R459 VGND.n715 VGND.n714 585
R460 VGND.n717 VGND.n594 585
R461 VGND.n570 VGND.n569 585
R462 VGND.n855 VGND.n570 585
R463 VGND.n858 VGND.n857 585
R464 VGND.n857 VGND.n856 585
R465 VGND.n859 VGND.n567 585
R466 VGND.n567 VGND.n566 585
R467 VGND.n861 VGND.n860 585
R468 VGND.n862 VGND.n861 585
R469 VGND.n568 VGND.n564 585
R470 VGND.n863 VGND.n564 585
R471 VGND.n866 VGND.n865 585
R472 VGND.n865 VGND.n864 585
R473 VGND.n867 VGND.n563 585
R474 VGND.n565 VGND.n563 585
R475 VGND.n869 VGND.n868 585
R476 VGND.n870 VGND.n869 585
R477 VGND.n562 VGND.n561 585
R478 VGND.n871 VGND.n562 585
R479 VGND.n874 VGND.n873 585
R480 VGND.n873 VGND.n872 585
R481 VGND.n875 VGND.n560 585
R482 VGND.n560 VGND.n559 585
R483 VGND.n877 VGND.n876 585
R484 VGND.n878 VGND.n877 585
R485 VGND.n1346 VGND.n1345 585
R486 VGND.n1337 VGND.n1020 585
R487 VGND.n1328 VGND.n1019 585
R488 VGND.n1332 VGND.n1330 585
R489 VGND.n1327 VGND.n1326 585
R490 VGND.n1323 VGND.n1322 585
R491 VGND.n1321 VGND.n1320 585
R492 VGND.n1317 VGND.n1316 585
R493 VGND.n1315 VGND.n1314 585
R494 VGND.n1311 VGND.n1310 585
R495 VGND.n1536 VGND.n1535 585
R496 VGND.n1509 VGND.n271 585
R497 VGND.n1513 VGND.n1508 585
R498 VGND.n1518 VGND.n1517 585
R499 VGND.n1515 VGND.n250 585
R500 VGND.n1514 VGND.n249 585
R501 VGND.n1605 VGND.n1604 585
R502 VGND.n1615 VGND.n1614 585
R503 VGND.n1612 VGND.n238 585
R504 VGND.n1611 VGND.n237 585
R505 VGND.n1497 VGND.n273 585
R506 VGND.n1498 VGND.n1497 585
R507 VGND.n1496 VGND.n1495 585
R508 VGND.n1496 VGND.n278 585
R509 VGND.n280 VGND.n279 585
R510 VGND.n1492 VGND.n279 585
R511 VGND.n1490 VGND.n1489 585
R512 VGND.n1491 VGND.n1490 585
R513 VGND.n1488 VGND.n283 585
R514 VGND.n283 VGND.n282 585
R515 VGND.n1484 VGND.n284 585
R516 VGND.n1485 VGND.n1484 585
R517 VGND.n1483 VGND.n1482 585
R518 VGND.n1483 VGND.n286 585
R519 VGND.n1481 VGND.n287 585
R520 VGND.n1479 VGND.n287 585
R521 VGND.n1477 VGND.n288 585
R522 VGND.n1478 VGND.n1477 585
R523 VGND.n1476 VGND.n1475 585
R524 VGND.n1476 VGND.n290 585
R525 VGND.n292 VGND.n291 585
R526 VGND.n1472 VGND.n291 585
R527 VGND.n1473 VGND.n292 585
R528 VGND.n1473 VGND.n1472 585
R529 VGND.n1475 VGND.n1474 585
R530 VGND.n1474 VGND.n290 585
R531 VGND.n289 VGND.n288 585
R532 VGND.n1478 VGND.n289 585
R533 VGND.n1481 VGND.n1480 585
R534 VGND.n1480 VGND.n1479 585
R535 VGND.n1482 VGND.n285 585
R536 VGND.n286 VGND.n285 585
R537 VGND.n1486 VGND.n284 585
R538 VGND.n1486 VGND.n1485 585
R539 VGND.n1488 VGND.n1487 585
R540 VGND.n1487 VGND.n282 585
R541 VGND.n1489 VGND.n281 585
R542 VGND.n1491 VGND.n281 585
R543 VGND.n1493 VGND.n280 585
R544 VGND.n1493 VGND.n1492 585
R545 VGND.n1495 VGND.n1494 585
R546 VGND.n1494 VGND.n278 585
R547 VGND.n276 VGND.n273 585
R548 VGND.n1498 VGND.n276 585
R549 VGND.n1384 VGND.n1383 585
R550 VGND.n1382 VGND.n348 585
R551 VGND.n1382 VGND.n1381 585
R552 VGND.n1470 VGND.n295 585
R553 VGND.n1470 VGND.n1469 585
R554 VGND.n753 VGND.n293 585
R555 VGND.n1381 VGND.n293 585
R556 VGND.n748 VGND.n367 585
R557 VGND.n756 VGND.n593 585
R558 VGND.n747 VGND.n347 585
R559 VGND.n756 VGND.n755 585
R560 VGND.n719 VGND.n367 585
R561 VGND.n718 VGND.n295 585
R562 VGND.n718 VGND.n314 585
R563 VGND.n853 VGND.n852 585
R564 VGND.n854 VGND.n853 585
R565 VGND.n592 VGND.n589 585
R566 VGND.n757 VGND.n592 585
R567 VGND.n760 VGND.n588 585
R568 VGND.n758 VGND.n588 585
R569 VGND.n761 VGND.n587 585
R570 VGND.n591 VGND.n587 585
R571 VGND.n762 VGND.n586 585
R572 VGND.n586 VGND.n366 585
R573 VGND.n585 VGND.n583 585
R574 VGND.n585 VGND.n365 585
R575 VGND.n767 VGND.n582 585
R576 VGND.n765 VGND.n582 585
R577 VGND.n768 VGND.n581 585
R578 VGND.n581 VGND.n578 585
R579 VGND.n769 VGND.n577 585
R580 VGND.n771 VGND.n577 585
R581 VGND.n580 VGND.n576 585
R582 VGND.n772 VGND.n576 585
R583 VGND.n574 VGND.n572 585
R584 VGND.n773 VGND.n572 585
R585 VGND.n852 VGND.n851 585
R586 VGND.n851 VGND.n850 585
R587 VGND.n774 VGND.n574 585
R588 VGND.n774 VGND.n773 585
R589 VGND.n580 VGND.n575 585
R590 VGND.n772 VGND.n575 585
R591 VGND.n770 VGND.n769 585
R592 VGND.n771 VGND.n770 585
R593 VGND.n768 VGND.n579 585
R594 VGND.n579 VGND.n578 585
R595 VGND.n767 VGND.n766 585
R596 VGND.n766 VGND.n765 585
R597 VGND.n764 VGND.n583 585
R598 VGND.n764 VGND.n365 585
R599 VGND.n763 VGND.n762 585
R600 VGND.n763 VGND.n366 585
R601 VGND.n761 VGND.n584 585
R602 VGND.n591 VGND.n584 585
R603 VGND.n760 VGND.n759 585
R604 VGND.n759 VGND.n758 585
R605 VGND.n590 VGND.n589 585
R606 VGND.n757 VGND.n590 585
R607 VGND.n787 VGND.n786 585
R608 VGND.n826 VGND.n787 585
R609 VGND.n829 VGND.n828 585
R610 VGND.n828 VGND.n827 585
R611 VGND.n830 VGND.n784 585
R612 VGND.n784 VGND.n783 585
R613 VGND.n832 VGND.n831 585
R614 VGND.n833 VGND.n832 585
R615 VGND.n785 VGND.n782 585
R616 VGND.n834 VGND.n782 585
R617 VGND.n837 VGND.n836 585
R618 VGND.n836 VGND.n835 585
R619 VGND.n838 VGND.n781 585
R620 VGND.n781 VGND.n780 585
R621 VGND.n840 VGND.n839 585
R622 VGND.n841 VGND.n840 585
R623 VGND.n779 VGND.n778 585
R624 VGND.n842 VGND.n779 585
R625 VGND.n845 VGND.n844 585
R626 VGND.n844 VGND.n843 585
R627 VGND.n846 VGND.n777 585
R628 VGND.n777 VGND.n776 585
R629 VGND.n848 VGND.n847 585
R630 VGND.n849 VGND.n848 585
R631 VGND.n824 VGND.n823 585
R632 VGND.n825 VGND.n824 585
R633 VGND.n803 VGND.n802 585
R634 VGND.n804 VGND.n803 585
R635 VGND.n800 VGND.n799 585
R636 VGND.n805 VGND.n800 585
R637 VGND.n808 VGND.n807 585
R638 VGND.n807 VGND.n806 585
R639 VGND.n809 VGND.n798 585
R640 VGND.n798 VGND.n369 585
R641 VGND.n811 VGND.n810 585
R642 VGND.n811 VGND.n368 585
R643 VGND.n813 VGND.n812 585
R644 VGND.n812 VGND.n797 585
R645 VGND.n815 VGND.n814 585
R646 VGND.n816 VGND.n815 585
R647 VGND.n795 VGND.n794 585
R648 VGND.n817 VGND.n795 585
R649 VGND.n820 VGND.n819 585
R650 VGND.n819 VGND.n818 585
R651 VGND.n821 VGND.n793 585
R652 VGND.n796 VGND.n793 585
R653 VGND.n350 VGND.n296 585
R654 VGND.n1469 VGND.n296 585
R655 VGND.n1375 VGND.n1374 585
R656 VGND.n1381 VGND.n1375 585
R657 VGND.n1002 VGND.n358 585
R658 VGND.n1002 VGND.n1001 585
R659 VGND.n801 VGND.n360 585
R660 VGND.n361 VGND.n360 585
R661 VGND.n1004 VGND.n1003 585
R662 VGND.n1003 VGND.n314 585
R663 VGND.n1353 VGND.n1352 585
R664 VGND.n1352 VGND.n1351 585
R665 VGND.n1354 VGND.n1010 585
R666 VGND.n1010 VGND.n1009 585
R667 VGND.n1356 VGND.n1355 585
R668 VGND.n1357 VGND.n1356 585
R669 VGND.n1011 VGND.n1008 585
R670 VGND.n1358 VGND.n1008 585
R671 VGND.n1360 VGND.n1007 585
R672 VGND.n1360 VGND.n1359 585
R673 VGND.n1363 VGND.n1362 585
R674 VGND.n1362 VGND.n1361 585
R675 VGND.n1365 VGND.n355 585
R676 VGND.n355 VGND.n354 585
R677 VGND.n1367 VGND.n1366 585
R678 VGND.n1368 VGND.n1367 585
R679 VGND.n352 VGND.n351 585
R680 VGND.n1369 VGND.n352 585
R681 VGND.n1372 VGND.n1371 585
R682 VGND.n1371 VGND.n1370 585
R683 VGND.n1373 VGND.n349 585
R684 VGND.n353 VGND.n349 585
R685 VGND.n1349 VGND.n1012 585
R686 VGND.n1350 VGND.n1349 585
R687 VGND.n1348 VGND.n1347 585
R688 VGND.n1348 VGND.n13 585
R689 VGND.n1078 VGND.n1077 585
R690 VGND.n1345 VGND.n1015 585
R691 VGND.n1337 VGND.n1336 585
R692 VGND.n1334 VGND.n1019 585
R693 VGND.n1333 VGND.n1332 585
R694 VGND.n1326 VGND.n1325 585
R695 VGND.n1324 VGND.n1323 585
R696 VGND.n1320 VGND.n1319 585
R697 VGND.n1318 VGND.n1317 585
R698 VGND.n1314 VGND.n1313 585
R699 VGND.n1312 VGND.n1311 585
R700 VGND.n1079 VGND.n23 585
R701 VGND.n1979 VGND.n23 585
R702 VGND.n1204 VGND.n1203 585
R703 VGND.n1100 VGND.n1068 585
R704 VGND.n1099 VGND.n1098 585
R705 VGND.n1096 VGND.n1069 585
R706 VGND.n1094 VGND.n1093 585
R707 VGND.n1092 VGND.n1070 585
R708 VGND.n1091 VGND.n1090 585
R709 VGND.n1088 VGND.n1087 585
R710 VGND.n1086 VGND.n1085 585
R711 VGND.n1084 VGND.n1074 585
R712 VGND.n1082 VGND.n1081 585
R713 VGND.n1080 VGND.n1075 585
R714 VGND.n1075 VGND.n15 585
R715 VGND.n1185 VGND.n1184 585
R716 VGND.n1185 VGND.n15 585
R717 VGND.n1187 VGND.n1066 585
R718 VGND.n1189 VGND.n1188 585
R719 VGND.n1191 VGND.n1065 585
R720 VGND.n1193 VGND.n1192 585
R721 VGND.n1195 VGND.n1194 585
R722 VGND.n1197 VGND.n1196 585
R723 VGND.n1198 VGND.n1062 585
R724 VGND.n1200 VGND.n1199 585
R725 VGND.n1202 VGND.n1060 585
R726 VGND.n1207 VGND.n1206 585
R727 VGND.n1206 VGND.n1205 585
R728 VGND.n1232 VGND.n274 585
R729 VGND.n1230 VGND.n1229 585
R730 VGND.n1034 VGND.n1033 585
R731 VGND.n1224 VGND.n1039 585
R732 VGND.n1223 VGND.n1040 585
R733 VGND.n1222 VGND.n1042 585
R734 VGND.n1046 VGND.n1043 585
R735 VGND.n1217 VGND.n1048 585
R736 VGND.n1216 VGND.n1049 585
R737 VGND.n1215 VGND.n1051 585
R738 VGND.n1055 VGND.n1052 585
R739 VGND.n1210 VGND.n1057 585
R740 VGND.n1234 VGND.n275 585
R741 VGND.n1501 VGND.n24 585
R742 VGND.n1979 VGND.n24 585
R743 VGND.n1505 VGND.n272 585
R744 VGND.n1499 VGND.n272 585
R745 VGND.n1533 VGND.n1532 585
R746 VGND.n1501 VGND.n1500 585
R747 VGND.n1500 VGND.n1499 585
R748 VGND.n277 VGND.n275 585
R749 VGND.n277 VGND.n13 585
R750 VGND.n1504 VGND.n22 585
R751 VGND.n1979 VGND.n22 585
R752 VGND.n1621 VGND.n1620 585
R753 VGND.n241 VGND.n236 585
R754 VGND.n247 VGND.n242 585
R755 VGND.n1603 VGND.n1602 585
R756 VGND.n1600 VGND.n1599 585
R757 VGND.n1510 VGND.n248 585
R758 VGND.n1519 VGND.n1507 585
R759 VGND.n1525 VGND.n1524 585
R760 VGND.n1527 VGND.n269 585
R761 VGND.n1528 VGND.n270 585
R762 VGND.n1531 VGND.n1530 585
R763 VGND.n1211 VGND.n1210 585
R764 VGND.n1213 VGND.n1052 585
R765 VGND.n1215 VGND.n1214 585
R766 VGND.n1216 VGND.n1045 585
R767 VGND.n1218 VGND.n1217 585
R768 VGND.n1220 VGND.n1043 585
R769 VGND.n1222 VGND.n1221 585
R770 VGND.n1223 VGND.n1037 585
R771 VGND.n1225 VGND.n1224 585
R772 VGND.n1227 VGND.n1034 585
R773 VGND.n1229 VGND.n1228 585
R774 VGND.n1035 VGND.n274 585
R775 VGND.n1208 VGND.n199 585
R776 VGND.n1799 VGND.n199 585
R777 VGND.n1784 VGND.n221 585
R778 VGND.n1895 VGND.n1894 585
R779 VGND.n1892 VGND.n82 585
R780 VGND.n1891 VGND.n78 585
R781 VGND.n1906 VGND.n76 585
R782 VGND.n1912 VGND.n1911 585
R783 VGND.n1915 VGND.n1914 585
R784 VGND.n75 VGND.n72 585
R785 VGND.n68 VGND.n64 585
R786 VGND.n1934 VGND.n1933 585
R787 VGND.n1931 VGND.n1930 585
R788 VGND.n65 VGND.n53 585
R789 VGND.n1936 VGND.n1935 585
R790 VGND.n69 VGND.n61 585
R791 VGND.n1919 VGND.n1918 585
R792 VGND.n1917 VGND.n1916 585
R793 VGND.n1910 VGND.n1909 585
R794 VGND.n1908 VGND.n1907 585
R795 VGND.n1900 VGND.n1899 585
R796 VGND.n1898 VGND.n1897 585
R797 VGND.n84 VGND.n83 585
R798 VGND.n446 VGND.n445 585
R799 VGND.n443 VGND.n442 585
R800 VGND.n437 VGND.n420 585
R801 VGND.n428 VGND.n427 585
R802 VGND.n425 VGND.n400 585
R803 VGND.n399 VGND.n393 585
R804 VGND.n971 VGND.n970 585
R805 VGND.n974 VGND.n973 585
R806 VGND.n392 VGND.n387 585
R807 VGND.n939 VGND.n386 585
R808 VGND.n327 VGND.n10 585
R809 VGND.n431 VGND.n419 585
R810 VGND.n432 VGND.n418 585
R811 VGND.n434 VGND.n421 585
R812 VGND.n436 VGND.n435 585
R813 VGND.n422 VGND.n398 585
R814 VGND.n966 VGND.n965 585
R815 VGND.n969 VGND.n968 585
R816 VGND.n397 VGND.n391 585
R817 VGND.n390 VGND.n385 585
R818 VGND.n980 VGND.n979 585
R819 VGND.n882 VGND.n881 585
R820 VGND.n883 VGND.n882 585
R821 VGND.n538 VGND.n531 585
R822 VGND.n540 VGND.n531 585
R823 VGND.n534 VGND.n530 585
R824 VGND.n541 VGND.n530 585
R825 VGND.n529 VGND.n528 585
R826 VGND.n542 VGND.n529 585
R827 VGND.n526 VGND.n525 585
R828 VGND.n525 VGND.n363 585
R829 VGND.n547 VGND.n546 585
R830 VGND.n547 VGND.n362 585
R831 VGND.n548 VGND.n522 585
R832 VGND.n549 VGND.n548 585
R833 VGND.n552 VGND.n521 585
R834 VGND.n550 VGND.n521 585
R835 VGND.n553 VGND.n520 585
R836 VGND.n524 VGND.n520 585
R837 VGND.n554 VGND.n519 585
R838 VGND.n519 VGND.n517 585
R839 VGND.n515 VGND.n513 585
R840 VGND.n557 VGND.n513 585
R841 VGND.n881 VGND.n880 585
R842 VGND.n880 VGND.n879 585
R843 VGND.n556 VGND.n515 585
R844 VGND.n557 VGND.n556 585
R845 VGND.n555 VGND.n554 585
R846 VGND.n555 VGND.n517 585
R847 VGND.n553 VGND.n518 585
R848 VGND.n524 VGND.n518 585
R849 VGND.n552 VGND.n551 585
R850 VGND.n551 VGND.n550 585
R851 VGND.n523 VGND.n522 585
R852 VGND.n549 VGND.n523 585
R853 VGND.n546 VGND.n545 585
R854 VGND.n545 VGND.n362 585
R855 VGND.n544 VGND.n526 585
R856 VGND.n544 VGND.n363 585
R857 VGND.n543 VGND.n528 585
R858 VGND.n543 VGND.n542 585
R859 VGND.n534 VGND.n527 585
R860 VGND.n541 VGND.n527 585
R861 VGND.n539 VGND.n538 585
R862 VGND.n540 VGND.n539 585
R863 VGND.n512 VGND.n511 585
R864 VGND.n884 VGND.n512 585
R865 VGND.n887 VGND.n886 585
R866 VGND.n886 VGND.n885 585
R867 VGND.n888 VGND.n509 585
R868 VGND.n509 VGND.n508 585
R869 VGND.n890 VGND.n889 585
R870 VGND.n891 VGND.n890 585
R871 VGND.n510 VGND.n507 585
R872 VGND.n892 VGND.n507 585
R873 VGND.n895 VGND.n894 585
R874 VGND.n894 VGND.n893 585
R875 VGND.n896 VGND.n506 585
R876 VGND.n506 VGND.n505 585
R877 VGND.n898 VGND.n897 585
R878 VGND.n899 VGND.n898 585
R879 VGND.n503 VGND.n500 585
R880 VGND.n900 VGND.n503 585
R881 VGND.n903 VGND.n902 585
R882 VGND.n902 VGND.n901 585
R883 VGND.n502 VGND.n499 585
R884 VGND.n504 VGND.n502 585
R885 VGND.n501 VGND.n374 585
R886 VGND.n501 VGND.n371 585
R887 VGND.n999 VGND.n998 585
R888 VGND.n1000 VGND.n999 585
R889 VGND.n375 VGND.n370 585
R890 VGND.n998 VGND.n997 585
R891 VGND.n995 VGND.n994 585
R892 VGND.n993 VGND.n992 585
R893 VGND.n991 VGND.n380 585
R894 VGND.n989 VGND.n988 585
R895 VGND.n987 VGND.n381 585
R896 VGND.n941 VGND.n940 585
R897 VGND.n940 VGND.n10 585
R898 VGND.n936 VGND.n486 585
R899 VGND.n936 VGND.n303 585
R900 VGND.n986 VGND.n985 585
R901 VGND.n983 VGND.n383 585
R902 VGND.n983 VGND.n370 585
R903 VGND.n982 VGND.n384 585
R904 VGND.n935 VGND.n934 585
R905 VGND.n933 VGND.n932 585
R906 VGND.n931 VGND.n488 585
R907 VGND.n931 VGND.n930 585
R908 VGND.n495 VGND.n489 585
R909 VGND.n915 VGND.n914 585
R910 VGND.n917 VGND.n916 585
R911 VGND.n919 VGND.n918 585
R912 VGND.n921 VGND.n920 585
R913 VGND.n923 VGND.n922 585
R914 VGND.n925 VGND.n924 585
R915 VGND.n926 VGND.n494 585
R916 VGND.n1887 VGND.n25 585
R917 VGND.n1979 VGND.n25 585
R918 VGND.n1889 VGND.n1888 585
R919 VGND.n1889 VGND.n12 585
R920 VGND.n929 VGND.n928 585
R921 VGND.n930 VGND.n929 585
R922 VGND.n927 VGND.n56 585
R923 VGND.n1938 VGND.n56 585
R924 VGND.n1886 VGND.n1885 585
R925 VGND.n1883 VGND.n152 585
R926 VGND.n1882 VGND.n1881 585
R927 VGND.n1882 VGND.n20 585
R928 VGND.n1880 VGND.n153 585
R929 VGND.n1746 VGND.n154 585
R930 VGND.n1748 VGND.n1747 585
R931 VGND.n1750 VGND.n1744 585
R932 VGND.n1753 VGND.n1752 585
R933 VGND.n1754 VGND.n1743 585
R934 VGND.n1756 VGND.n1755 585
R935 VGND.n1758 VGND.n1742 585
R936 VGND.n1779 VGND.n1778 585
R937 VGND.n1778 VGND.n20 585
R938 VGND.n1777 VGND.n14 585
R939 VGND.n1775 VGND.n1774 585
R940 VGND.n1773 VGND.n1759 585
R941 VGND.n1772 VGND.n1771 585
R942 VGND.n1769 VGND.n1760 585
R943 VGND.n1767 VGND.n1766 585
R944 VGND.n1765 VGND.n1761 585
R945 VGND.n1764 VGND.n1763 585
R946 VGND.n220 VGND.n219 585
R947 VGND.n222 VGND.n220 585
R948 VGND.n1786 VGND.n219 585
R949 VGND.n1786 VGND.n1785 585
R950 VGND.n165 VGND.n162 585
R951 VGND.n162 VGND.n161 585
R952 VGND.n208 VGND.n207 585
R953 VGND.n207 VGND.n206 585
R954 VGND.n198 VGND.n197 585
R955 VGND.n205 VGND.n198 585
R956 VGND.n1802 VGND.n1801 585
R957 VGND.n1801 VGND.n1800 585
R958 VGND.n192 VGND.n189 585
R959 VGND.n1861 VGND.n192 585
R960 VGND.n1864 VGND.n1863 585
R961 VGND.n1863 VGND.n1862 585
R962 VGND.n190 VGND.n158 585
R963 VGND.n160 VGND.n158 585
R964 VGND.n1876 VGND.n1875 585
R965 VGND.n1875 VGND.n1874 585
R966 VGND.n163 VGND.n159 585
R967 VGND.n1873 VGND.n159 585
R968 VGND.n1871 VGND.n1870 585
R969 VGND.n1872 VGND.n1871 585
R970 VGND.n1859 VGND.n1858 585
R971 VGND.n1860 VGND.n1859 585
R972 VGND.n1782 VGND.n1781 585
R973 VGND.n1783 VGND.n1782 585
R974 VGND.n1626 VGND.n1625 585
R975 VGND.n1628 VGND.n234 585
R976 VGND.n1631 VGND.n1630 585
R977 VGND.n231 VGND.n230 585
R978 VGND.n1638 VGND.n1637 585
R979 VGND.n1640 VGND.n229 585
R980 VGND.n1643 VGND.n1642 585
R981 VGND.n227 VGND.n226 585
R982 VGND.n1652 VGND.n1651 585
R983 VGND.n1654 VGND.n225 585
R984 VGND.n1655 VGND.n224 585
R985 VGND.n1658 VGND.n1657 585
R986 VGND.n1659 VGND.n1658 585
R987 VGND.n1647 VGND.n224 585
R988 VGND.n1648 VGND.n225 585
R989 VGND.n1651 VGND.n1650 585
R990 VGND.n1646 VGND.n227 585
R991 VGND.n1644 VGND.n1643 585
R992 VGND.n229 VGND.n228 585
R993 VGND.n1637 VGND.n1636 585
R994 VGND.n1634 VGND.n231 585
R995 VGND.n1632 VGND.n1631 585
R996 VGND.n234 VGND.n233 585
R997 VGND.n1625 VGND.n27 585
R998 VGND.n1607 VGND.n21 585
R999 VGND.n1979 VGND.n21 585
R1000 VGND.n1623 VGND.n235 585
R1001 VGND.n1978 VGND.n1977 585
R1002 VGND.n1979 VGND.n1978 585
R1003 VGND.n54 VGND.n26 585
R1004 VGND.n26 VGND.n12 585
R1005 VGND.n1940 VGND.n28 585
R1006 VGND.n1939 VGND.n55 585
R1007 VGND.n1939 VGND.n1938 585
R1008 VGND.n1606 VGND.n31 585
R1009 VGND.n1609 VGND.n1608 585
R1010 VGND.n1942 VGND.n30 585
R1011 VGND.n1944 VGND.n1943 585
R1012 VGND.n1947 VGND.n50 585
R1013 VGND.n1952 VGND.n1951 585
R1014 VGND.n1955 VGND.n1954 585
R1015 VGND.n49 VGND.n46 585
R1016 VGND.n1960 VGND.n44 585
R1017 VGND.n1964 VGND.n1963 585
R1018 VGND.n1966 VGND.n42 585
R1019 VGND.n1968 VGND.n1967 585
R1020 VGND.n1376 VGND.n39 585
R1021 VGND.n1970 VGND.n1969 585
R1022 VGND.n40 VGND.n37 585
R1023 VGND.n45 VGND.n36 585
R1024 VGND.n1972 VGND.n36 585
R1025 VGND.n1962 VGND.n1961 585
R1026 VGND.n1959 VGND.n1958 585
R1027 VGND.n1957 VGND.n1956 585
R1028 VGND.n1948 VGND.n47 585
R1029 VGND.n1950 VGND.n1949 585
R1030 VGND.n1946 VGND.n1945 585
R1031 VGND.n51 VGND.n32 585
R1032 VGND.n1975 VGND.n1974 585
R1033 VGND.n1378 VGND.n1377 585
R1034 VGND.n1377 VGND.n303 585
R1035 VGND.n329 VGND.n328 585
R1036 VGND.n1380 VGND.n1379 585
R1037 VGND.n1381 VGND.n1380 585
R1038 VGND.n535 VGND.n324 585
R1039 VGND.n535 VGND.n364 585
R1040 VGND.n537 VGND.n536 585
R1041 VGND.n536 VGND.n532 585
R1042 VGND.n537 VGND.n533 585
R1043 VGND.n533 VGND.n532 585
R1044 VGND.n324 VGND.n323 585
R1045 VGND.n364 VGND.n323 585
R1046 VGND.n1444 VGND.n1443 585
R1047 VGND.n741 VGND.n740 585
R1048 VGND.n739 VGND.n738 585
R1049 VGND.n731 VGND.n730 585
R1050 VGND.n729 VGND.n728 585
R1051 VGND.n319 VGND.n318 585
R1052 VGND.n317 VGND.n316 585
R1053 VGND.n496 VGND.n309 585
R1054 VGND.n1467 VGND.n1466 585
R1055 VGND.n1449 VGND.n308 585
R1056 VGND.n1439 VGND.n1438 585
R1057 VGND.n745 VGND.n346 585
R1058 VGND.n744 VGND.n743 585
R1059 VGND.n723 VGND.n721 585
R1060 VGND.n725 VGND.n724 585
R1061 VGND.n726 VGND.n315 585
R1062 VGND.n1461 VGND.n1460 585
R1063 VGND.n1463 VGND.n313 585
R1064 VGND.n1465 VGND.n1464 585
R1065 VGND.n1448 VGND.n1447 585
R1066 VGND.n1446 VGND.n322 585
R1067 VGND.n1984 VGND.n6 584.5
R1068 VGND.n1207 VGND.n212 581.466
R1069 VGND.t6 VGND.n1000 533.261
R1070 VGND.n791 VGND.n789 525.067
R1071 VGND.t18 VGND.t25 483.543
R1072 VGND.n1205 VGND.t19 446.469
R1073 VGND.n796 VGND.n792 425.445
R1074 VGND.n353 VGND.t32 425.445
R1075 VGND.n1983 VGND.n8 423.154
R1076 VGND.n905 VGND.n904 416
R1077 VGND.n1981 VGND.t25 401.75
R1078 VGND.t29 VGND.t28 396.397
R1079 VGND.t28 VGND.t26 396.397
R1080 VGND.t19 VGND.t27 396.397
R1081 VGND.n558 VGND.n557 368.283
R1082 VGND.n773 VGND.n571 368.283
R1083 VGND.n1472 VGND.t32 366.668
R1084 VGND.n854 VGND.n571 361.087
R1085 VGND.n879 VGND.n558 358.697
R1086 VGND.n850 VGND.n571 358.697
R1087 VGND.n1972 VGND.t32 219.123
R1088 VGND.n883 VGND.t4 330
R1089 VGND.n930 VGND.t39 315.904
R1090 VGND.t41 VGND.n17 216.516
R1091 VGND.t41 VGND.n19 216.516
R1092 VGND.t41 VGND.n20 315.914
R1093 VGND.t34 VGND.n368 324.683
R1094 VGND.n1361 VGND.t32 324.683
R1095 VGND.t41 VGND.n15 198.639
R1096 VGND.t41 VGND.n16 215.129
R1097 VGND.t41 VGND.n18 215.129
R1098 VGND.t34 VGND.n370 315.914
R1099 VGND.t34 VGND.t9 301.305
R1100 VGND.n1986 VGND.n6 295.945
R1101 VGND.n1982 VGND.n1981 292.5
R1102 VGND.n825 VGND.n792 289.349
R1103 VGND.t34 VGND.n362 281.058
R1104 VGND.t34 VGND.n365 281.058
R1105 VGND.n1485 VGND.t32 279.825
R1106 VGND.n211 VGND.n210 279.818
R1107 VGND.n0 VGND.t32 8.41859
R1108 VGND.n1163 VGND.n1101 262.705
R1109 VGND.n1805 VGND.n1804 258.334
R1110 VGND.n449 VGND.n448 258.334
R1111 VGND.n1738 VGND.n1737 258.334
R1112 VGND.n1126 VGND.n1114 258.334
R1113 VGND.n1342 VGND.n1341 258.334
R1114 VGND.n656 VGND.n655 258.334
R1115 VGND.n1539 VGND.n1538 258.334
R1116 VGND.n1927 VGND.n1926 258.334
R1117 VGND.n1387 VGND.n345 258.334
R1118 VGND.n1444 VGND.n323 257.466
R1119 VGND.n719 VGND.n718 257.466
R1120 VGND.n1500 VGND.n277 257.466
R1121 VGND.n1609 VGND.n31 257.466
R1122 VGND.n1778 VGND.n1777 257.466
R1123 VGND.n929 VGND.n56 257.466
R1124 VGND.n983 VGND.n982 257.466
R1125 VGND.n1469 VGND.n302 254.34
R1126 VGND.n1469 VGND.n301 254.34
R1127 VGND.n1469 VGND.n300 254.34
R1128 VGND.n1469 VGND.n299 254.34
R1129 VGND.n1469 VGND.n298 254.34
R1130 VGND.n649 VGND.n314 254.34
R1131 VGND.n621 VGND.n314 254.34
R1132 VGND.n624 VGND.n314 254.34
R1133 VGND.n628 VGND.n314 254.34
R1134 VGND.n716 VGND.n314 254.34
R1135 VGND.n1013 VGND.n13 254.34
R1136 VGND.n1329 VGND.n13 254.34
R1137 VGND.n1023 VGND.n13 254.34
R1138 VGND.n1027 VGND.n13 254.34
R1139 VGND.n1031 VGND.n13 254.34
R1140 VGND.n1512 VGND.n13 254.34
R1141 VGND.n1516 VGND.n13 254.34
R1142 VGND.n243 VGND.n13 254.34
R1143 VGND.n1613 VGND.n13 254.34
R1144 VGND.n1469 VGND.n297 254.34
R1145 VGND.n750 VGND.n749 254.34
R1146 VGND.n746 VGND.n314 254.34
R1147 VGND.n754 VGND.n753 254.34
R1148 VGND.n1076 VGND.n12 254.34
R1149 VGND.n1335 VGND.n12 254.34
R1150 VGND.n1021 VGND.n12 254.34
R1151 VGND.n1025 VGND.n12 254.34
R1152 VGND.n1029 VGND.n12 254.34
R1153 VGND.n1235 VGND.n12 254.34
R1154 VGND.n1097 VGND.n15 254.34
R1155 VGND.n1095 VGND.n15 254.34
R1156 VGND.n1089 VGND.n15 254.34
R1157 VGND.n1073 VGND.n15 254.34
R1158 VGND.n1083 VGND.n15 254.34
R1159 VGND.n1067 VGND.n1061 254.34
R1160 VGND.n1190 VGND.n1061 254.34
R1161 VGND.n1064 VGND.n1061 254.34
R1162 VGND.n1063 VGND.n1061 254.34
R1163 VGND.n1201 VGND.n1061 254.34
R1164 VGND.n1231 VGND.n17 254.34
R1165 VGND.n1038 VGND.n17 254.34
R1166 VGND.n1041 VGND.n17 254.34
R1167 VGND.n1047 VGND.n17 254.34
R1168 VGND.n1050 VGND.n17 254.34
R1169 VGND.n1056 VGND.n17 254.34
R1170 VGND.n1534 VGND.n13 254.34
R1171 VGND.n1622 VGND.n12 254.34
R1172 VGND.n246 VGND.n12 254.34
R1173 VGND.n1601 VGND.n12 254.34
R1174 VGND.n1506 VGND.n12 254.34
R1175 VGND.n1526 VGND.n12 254.34
R1176 VGND.n1529 VGND.n12 254.34
R1177 VGND.n1212 VGND.n16 254.34
R1178 VGND.n1053 VGND.n16 254.34
R1179 VGND.n1219 VGND.n16 254.34
R1180 VGND.n1044 VGND.n16 254.34
R1181 VGND.n1226 VGND.n16 254.34
R1182 VGND.n1036 VGND.n16 254.34
R1183 VGND.n1893 VGND.n12 254.34
R1184 VGND.n1890 VGND.n12 254.34
R1185 VGND.n1913 VGND.n12 254.34
R1186 VGND.n74 VGND.n12 254.34
R1187 VGND.n1932 VGND.n12 254.34
R1188 VGND.n1938 VGND.n1937 254.34
R1189 VGND.n1938 VGND.n60 254.34
R1190 VGND.n1938 VGND.n59 254.34
R1191 VGND.n1938 VGND.n58 254.34
R1192 VGND.n1938 VGND.n57 254.34
R1193 VGND.n444 VGND.n10 254.34
R1194 VGND.n426 VGND.n10 254.34
R1195 VGND.n424 VGND.n10 254.34
R1196 VGND.n972 VGND.n10 254.34
R1197 VGND.n938 VGND.n10 254.34
R1198 VGND.n430 VGND.n314 254.34
R1199 VGND.n433 VGND.n314 254.34
R1200 VGND.n429 VGND.n314 254.34
R1201 VGND.n967 VGND.n314 254.34
R1202 VGND.n396 VGND.n314 254.34
R1203 VGND.n981 VGND.n314 254.34
R1204 VGND.n998 VGND.n376 254.34
R1205 VGND.n377 VGND.n370 254.34
R1206 VGND.n998 VGND.n378 254.34
R1207 VGND.n996 VGND.n370 254.34
R1208 VGND.n379 VGND.n370 254.34
R1209 VGND.n990 VGND.n370 254.34
R1210 VGND.n984 VGND.n370 254.34
R1211 VGND.n930 VGND.n487 254.34
R1212 VGND.n930 VGND.n490 254.34
R1213 VGND.n930 VGND.n491 254.34
R1214 VGND.n930 VGND.n492 254.34
R1215 VGND.n930 VGND.n493 254.34
R1216 VGND.n1884 VGND.n20 254.34
R1217 VGND.n1745 VGND.n20 254.34
R1218 VGND.n1749 VGND.n20 254.34
R1219 VGND.n1751 VGND.n20 254.34
R1220 VGND.n1757 VGND.n20 254.34
R1221 VGND.n1776 VGND.n219 254.34
R1222 VGND.n1770 VGND.n219 254.34
R1223 VGND.n1768 VGND.n219 254.34
R1224 VGND.n1762 VGND.n219 254.34
R1225 VGND.n1627 VGND.n19 254.34
R1226 VGND.n1629 VGND.n19 254.34
R1227 VGND.n1639 VGND.n19 254.34
R1228 VGND.n1641 VGND.n19 254.34
R1229 VGND.n1653 VGND.n19 254.34
R1230 VGND.n1656 VGND.n19 254.34
R1231 VGND.n223 VGND.n18 254.34
R1232 VGND.n1649 VGND.n18 254.34
R1233 VGND.n1645 VGND.n18 254.34
R1234 VGND.n1635 VGND.n18 254.34
R1235 VGND.n1633 VGND.n18 254.34
R1236 VGND.n232 VGND.n18 254.34
R1237 VGND.n1941 VGND.n43 254.34
R1238 VGND.n1610 VGND.n13 254.34
R1239 VGND.n52 VGND.n43 254.34
R1240 VGND.n1953 VGND.n43 254.34
R1241 VGND.n48 VGND.n43 254.34
R1242 VGND.n1965 VGND.n43 254.34
R1243 VGND.n43 VGND.n41 254.34
R1244 VGND.n1972 VGND.n1971 254.34
R1245 VGND.n1972 VGND.n33 254.34
R1246 VGND.n1972 VGND.n34 254.34
R1247 VGND.n1972 VGND.n35 254.34
R1248 VGND.n1973 VGND.n1972 254.34
R1249 VGND.n1469 VGND.n304 254.34
R1250 VGND.n1445 VGND.n314 254.34
R1251 VGND.n1469 VGND.n305 254.34
R1252 VGND.n1469 VGND.n306 254.34
R1253 VGND.n1469 VGND.n307 254.34
R1254 VGND.n1469 VGND.n1468 254.34
R1255 VGND.n720 VGND.n314 254.34
R1256 VGND.n722 VGND.n314 254.34
R1257 VGND.n1462 VGND.n314 254.34
R1258 VGND.n314 VGND.n312 254.34
R1259 VGND.n1127 VGND.n1101 253.841
R1260 VGND.n748 VGND.n747 251.614
R1261 VGND.n1003 VGND.n1002 251.614
R1262 VGND.n1349 VGND.n1348 251.614
R1263 VGND.n1533 VGND.n272 251.614
R1264 VGND.n1186 VGND.n1185 251.614
R1265 VGND.n1940 VGND.n1939 251.614
R1266 VGND.n535 VGND.n326 251.614
R1267 VGND.n1866 VGND.n187 250
R1268 VGND.n1741 VGND.n1740 245.638
R1269 VGND.n1000 VGND.n371 241.523
R1270 VGND.n879 VGND.n878 241.523
R1271 VGND.n850 VGND.n849 241.523
R1272 VGND.n1741 VGND.n1663 234.006
R1273 VGND.n884 VGND.n883 229.565
R1274 VGND.n826 VGND.n825 229.565
R1275 VGND.n504 VGND.n371 215.218
R1276 VGND.n901 VGND.n504 215.218
R1277 VGND.n901 VGND.n900 215.218
R1278 VGND.n900 VGND.n899 215.218
R1279 VGND.n899 VGND.n505 215.218
R1280 VGND.n892 VGND.n891 215.218
R1281 VGND.n891 VGND.n508 215.218
R1282 VGND.n885 VGND.n508 215.218
R1283 VGND.n885 VGND.n884 215.218
R1284 VGND.n878 VGND.n559 215.218
R1285 VGND.n872 VGND.n559 215.218
R1286 VGND.n872 VGND.n871 215.218
R1287 VGND.n871 VGND.n870 215.218
R1288 VGND.n864 VGND.n863 215.218
R1289 VGND.n863 VGND.n862 215.218
R1290 VGND.n862 VGND.n566 215.218
R1291 VGND.n856 VGND.n566 215.218
R1292 VGND.n856 VGND.n855 215.218
R1293 VGND.n849 VGND.n776 215.218
R1294 VGND.n843 VGND.n776 215.218
R1295 VGND.n842 VGND.n841 215.218
R1296 VGND.n841 VGND.n780 215.218
R1297 VGND.n835 VGND.n834 215.218
R1298 VGND.n834 VGND.n833 215.218
R1299 VGND.n833 VGND.n783 215.218
R1300 VGND.n827 VGND.n826 215.218
R1301 VGND VGND.t13 202.4
R1302 VGND.n1172 VGND.n1162 200.326
R1303 VGND.n877 VGND.n516 195.049
R1304 VGND.n848 VGND.n775 195.049
R1305 VGND.n1471 VGND.n1470 195.049
R1306 VGND.n328 VGND.n38 195.049
R1307 VGND.n1234 VGND.n1233 195.049
R1308 VGND.n1624 VGND.n1623 195.049
R1309 VGND.n1889 VGND.n85 195.049
R1310 VGND.n940 VGND.n937 195.049
R1311 VGND.n501 VGND.n372 195.049
R1312 VGND.n1774 VGND.n14 187.768
R1313 VGND.n1774 VGND.n1773 187.768
R1314 VGND.n1773 VGND.n1772 187.768
R1315 VGND.n1772 VGND.n1760 187.768
R1316 VGND.n1766 VGND.n1760 187.768
R1317 VGND.n1765 VGND.n1764 187.768
R1318 VGND.n1764 VGND.n222 187.768
R1319 VGND.n1785 VGND.n222 187.768
R1320 VGND.n1785 VGND.n1784 187.768
R1321 VGND.n1784 VGND.n1783 187.768
R1322 VGND.n1860 VGND.n193 187.768
R1323 VGND.n1862 VGND.n1861 187.768
R1324 VGND.n1874 VGND.n160 187.768
R1325 VGND.n1874 VGND.n1873 187.768
R1326 VGND.n1872 VGND.n161 187.768
R1327 VGND.n206 VGND.n161 187.768
R1328 VGND.n206 VGND.n205 187.768
R1329 VGND.n1800 VGND.n1799 187.768
R1330 VGND.n1205 VGND.n1204 187.768
R1331 VGND.n1204 VGND.n1060 187.768
R1332 VGND.n1199 VGND.n1060 187.768
R1333 VGND.n1199 VGND.n1198 187.768
R1334 VGND.n1198 VGND.n1197 187.768
R1335 VGND.n1194 VGND.n1193 187.768
R1336 VGND.n1193 VGND.n1065 187.768
R1337 VGND.n1188 VGND.n1065 187.768
R1338 VGND.n1188 VGND.n1187 187.768
R1339 VGND.n853 VGND.n570 187.249
R1340 VGND.n824 VGND.n787 187.249
R1341 VGND.n1375 VGND.n296 187.249
R1342 VGND.n1383 VGND.n1382 187.249
R1343 VGND.n1077 VGND.n23 187.249
R1344 VGND.n1530 VGND.n22 187.249
R1345 VGND.n1978 VGND.n26 187.249
R1346 VGND.n1377 VGND.n327 187.249
R1347 VGND.n882 VGND.n512 187.249
R1348 VGND.n1172 VGND.n1163 185.38
R1349 VGND.n485 VGND.n416 185
R1350 VGND.n958 VGND.n957 185
R1351 VGND.n956 VGND.n417 185
R1352 VGND.n955 VGND.n954 185
R1353 VGND.n953 VGND.n952 185
R1354 VGND.n951 VGND.n950 185
R1355 VGND.n949 VGND.n948 185
R1356 VGND.n947 VGND.n946 185
R1357 VGND.n945 VGND.n944 185
R1358 VGND.n468 VGND.n467 185
R1359 VGND.n470 VGND.n469 185
R1360 VGND.n472 VGND.n471 185
R1361 VGND.n474 VGND.n473 185
R1362 VGND.n476 VGND.n475 185
R1363 VGND.n478 VGND.n477 185
R1364 VGND.n480 VGND.n479 185
R1365 VGND.n482 VGND.n481 185
R1366 VGND.n484 VGND.n483 185
R1367 VGND.n450 VGND.n449 185
R1368 VGND.n452 VGND.n451 185
R1369 VGND.n454 VGND.n453 185
R1370 VGND.n456 VGND.n455 185
R1371 VGND.n458 VGND.n457 185
R1372 VGND.n460 VGND.n459 185
R1373 VGND.n462 VGND.n461 185
R1374 VGND.n464 VGND.n463 185
R1375 VGND.n466 VGND.n465 185
R1376 VGND.n448 VGND.n447 185
R1377 VGND.n441 VGND.n440 185
R1378 VGND.n439 VGND.n438 185
R1379 VGND.n423 VGND.n401 185
R1380 VGND.n964 VGND.n963 185
R1381 VGND.n961 VGND.n395 185
R1382 VGND.n960 VGND.n394 185
R1383 VGND.n976 VGND.n975 185
R1384 VGND.n978 VGND.n977 185
R1385 VGND.n1713 VGND.n1712 185
R1386 VGND.n1714 VGND.n1669 185
R1387 VGND.n1716 VGND.n1715 185
R1388 VGND.n1718 VGND.n1668 185
R1389 VGND.n1721 VGND.n1720 185
R1390 VGND.n1722 VGND.n1667 185
R1391 VGND.n1724 VGND.n1723 185
R1392 VGND.n1726 VGND.n1666 185
R1393 VGND.n1727 VGND.n1663 185
R1394 VGND.n1694 VGND.n1674 185
R1395 VGND.n1697 VGND.n1696 185
R1396 VGND.n1698 VGND.n1673 185
R1397 VGND.n1700 VGND.n1699 185
R1398 VGND.n1702 VGND.n1672 185
R1399 VGND.n1705 VGND.n1704 185
R1400 VGND.n1706 VGND.n1671 185
R1401 VGND.n1708 VGND.n1707 185
R1402 VGND.n1710 VGND.n1670 185
R1403 VGND.n1739 VGND.n1738 185
R1404 VGND.n1680 VGND.n1664 185
R1405 VGND.n1682 VGND.n1681 185
R1406 VGND.n1683 VGND.n1678 185
R1407 VGND.n1685 VGND.n1684 185
R1408 VGND.n1687 VGND.n1676 185
R1409 VGND.n1689 VGND.n1688 185
R1410 VGND.n1690 VGND.n1675 185
R1411 VGND.n1692 VGND.n1691 185
R1412 VGND.n1737 VGND.n1661 185
R1413 VGND.n1283 VGND.n1282 185
R1414 VGND.n1284 VGND.n1239 185
R1415 VGND.n1286 VGND.n1285 185
R1416 VGND.n1288 VGND.n1238 185
R1417 VGND.n1291 VGND.n1290 185
R1418 VGND.n1292 VGND.n1237 185
R1419 VGND.n1294 VGND.n1293 185
R1420 VGND.n1296 VGND.n1236 185
R1421 VGND.n1308 VGND.n1307 185
R1422 VGND.n1264 VGND.n1244 185
R1423 VGND.n1267 VGND.n1266 185
R1424 VGND.n1268 VGND.n1243 185
R1425 VGND.n1270 VGND.n1269 185
R1426 VGND.n1272 VGND.n1242 185
R1427 VGND.n1275 VGND.n1274 185
R1428 VGND.n1276 VGND.n1241 185
R1429 VGND.n1278 VGND.n1277 185
R1430 VGND.n1280 VGND.n1240 185
R1431 VGND.n1343 VGND.n1342 185
R1432 VGND.n1250 VGND.n1016 185
R1433 VGND.n1252 VGND.n1251 185
R1434 VGND.n1253 VGND.n1248 185
R1435 VGND.n1255 VGND.n1254 185
R1436 VGND.n1257 VGND.n1246 185
R1437 VGND.n1259 VGND.n1258 185
R1438 VGND.n1260 VGND.n1245 185
R1439 VGND.n1262 VGND.n1261 185
R1440 VGND.n1341 VGND.n1014 185
R1441 VGND.n1339 VGND.n1338 185
R1442 VGND.n1331 VGND.n1018 185
R1443 VGND.n1298 VGND.n1022 185
R1444 VGND.n1299 VGND.n1024 185
R1445 VGND.n1301 VGND.n1026 185
R1446 VGND.n1302 VGND.n1028 185
R1447 VGND.n1304 VGND.n1030 185
R1448 VGND.n1305 VGND.n1032 185
R1449 VGND.n693 VGND.n692 185
R1450 VGND.n695 VGND.n694 185
R1451 VGND.n697 VGND.n696 185
R1452 VGND.n699 VGND.n698 185
R1453 VGND.n701 VGND.n700 185
R1454 VGND.n703 VGND.n702 185
R1455 VGND.n705 VGND.n704 185
R1456 VGND.n706 VGND.n618 185
R1457 VGND.n709 VGND.n708 185
R1458 VGND.n675 VGND.n674 185
R1459 VGND.n677 VGND.n676 185
R1460 VGND.n679 VGND.n678 185
R1461 VGND.n681 VGND.n680 185
R1462 VGND.n683 VGND.n682 185
R1463 VGND.n685 VGND.n684 185
R1464 VGND.n687 VGND.n686 185
R1465 VGND.n689 VGND.n688 185
R1466 VGND.n691 VGND.n690 185
R1467 VGND.n657 VGND.n656 185
R1468 VGND.n659 VGND.n658 185
R1469 VGND.n661 VGND.n660 185
R1470 VGND.n663 VGND.n662 185
R1471 VGND.n665 VGND.n664 185
R1472 VGND.n667 VGND.n666 185
R1473 VGND.n669 VGND.n668 185
R1474 VGND.n671 VGND.n670 185
R1475 VGND.n673 VGND.n672 185
R1476 VGND.n655 VGND.n654 185
R1477 VGND.n643 VGND.n619 185
R1478 VGND.n645 VGND.n644 185
R1479 VGND.n635 VGND.n622 185
R1480 VGND.n637 VGND.n636 185
R1481 VGND.n626 VGND.n625 185
R1482 VGND.n629 VGND.n601 185
R1483 VGND.n713 VGND.n712 185
R1484 VGND.n600 VGND.n596 185
R1485 VGND.n1575 VGND.n266 185
R1486 VGND.n1591 VGND.n1590 185
R1487 VGND.n1589 VGND.n267 185
R1488 VGND.n1588 VGND.n1587 185
R1489 VGND.n1586 VGND.n1585 185
R1490 VGND.n1584 VGND.n1583 185
R1491 VGND.n1582 VGND.n1581 185
R1492 VGND.n1580 VGND.n1579 185
R1493 VGND.n1578 VGND.n1577 185
R1494 VGND.n1558 VGND.n1557 185
R1495 VGND.n1560 VGND.n1559 185
R1496 VGND.n1562 VGND.n1561 185
R1497 VGND.n1564 VGND.n1563 185
R1498 VGND.n1566 VGND.n1565 185
R1499 VGND.n1568 VGND.n1567 185
R1500 VGND.n1570 VGND.n1569 185
R1501 VGND.n1572 VGND.n1571 185
R1502 VGND.n1574 VGND.n1573 185
R1503 VGND.n1540 VGND.n1539 185
R1504 VGND.n1542 VGND.n1541 185
R1505 VGND.n1544 VGND.n1543 185
R1506 VGND.n1546 VGND.n1545 185
R1507 VGND.n1548 VGND.n1547 185
R1508 VGND.n1550 VGND.n1549 185
R1509 VGND.n1552 VGND.n1551 185
R1510 VGND.n1554 VGND.n1553 185
R1511 VGND.n1556 VGND.n1555 185
R1512 VGND.n1538 VGND.n1537 185
R1513 VGND.n1523 VGND.n1522 185
R1514 VGND.n1521 VGND.n1520 185
R1515 VGND.n1511 VGND.n251 185
R1516 VGND.n1598 VGND.n1597 185
R1517 VGND.n1595 VGND.n1594 185
R1518 VGND.n1593 VGND.n244 185
R1519 VGND.n1617 VGND.n1616 185
R1520 VGND.n1619 VGND.n1618 185
R1521 VGND.n1125 VGND.n1123 185
R1522 VGND.n1179 VGND.n1178 185
R1523 VGND.n1177 VGND.n1124 185
R1524 VGND.n1176 VGND.n1175 185
R1525 VGND.n1174 VGND.n1173 185
R1526 VGND.n1171 VGND.n1170 185
R1527 VGND.n1169 VGND.n1168 185
R1528 VGND.n1167 VGND.n1166 185
R1529 VGND.n1165 VGND.n1164 185
R1530 VGND.n1145 VGND.n1144 185
R1531 VGND.n1147 VGND.n1146 185
R1532 VGND.n1149 VGND.n1148 185
R1533 VGND.n1151 VGND.n1150 185
R1534 VGND.n1153 VGND.n1152 185
R1535 VGND.n1155 VGND.n1154 185
R1536 VGND.n1157 VGND.n1156 185
R1537 VGND.n1159 VGND.n1158 185
R1538 VGND.n1161 VGND.n1160 185
R1539 VGND.n1127 VGND.n1126 185
R1540 VGND.n1129 VGND.n1128 185
R1541 VGND.n1131 VGND.n1130 185
R1542 VGND.n1133 VGND.n1132 185
R1543 VGND.n1135 VGND.n1134 185
R1544 VGND.n1137 VGND.n1136 185
R1545 VGND.n1139 VGND.n1138 185
R1546 VGND.n1141 VGND.n1140 185
R1547 VGND.n1143 VGND.n1142 185
R1548 VGND.t40 VGND.n1114 185
R1549 VGND.n1181 VGND.t40 185
R1550 VGND.n1183 VGND.n1182 185
R1551 VGND.n133 VGND.n132 185
R1552 VGND.n134 VGND.n89 185
R1553 VGND.n136 VGND.n135 185
R1554 VGND.n138 VGND.n88 185
R1555 VGND.n141 VGND.n140 185
R1556 VGND.n142 VGND.n87 185
R1557 VGND.n144 VGND.n143 185
R1558 VGND.n146 VGND.n86 185
R1559 VGND.n149 VGND.n148 185
R1560 VGND.n114 VGND.n94 185
R1561 VGND.n117 VGND.n116 185
R1562 VGND.n118 VGND.n93 185
R1563 VGND.n120 VGND.n119 185
R1564 VGND.n122 VGND.n92 185
R1565 VGND.n125 VGND.n124 185
R1566 VGND.n126 VGND.n91 185
R1567 VGND.n128 VGND.n127 185
R1568 VGND.n130 VGND.n90 185
R1569 VGND.n1928 VGND.n1927 185
R1570 VGND.n100 VGND.n66 185
R1571 VGND.n102 VGND.n101 185
R1572 VGND.n103 VGND.n98 185
R1573 VGND.n105 VGND.n104 185
R1574 VGND.n107 VGND.n96 185
R1575 VGND.n109 VGND.n108 185
R1576 VGND.n110 VGND.n95 185
R1577 VGND.n112 VGND.n111 185
R1578 VGND.n1926 VGND.n63 185
R1579 VGND.n1924 VGND.n62 185
R1580 VGND.n1923 VGND.n70 185
R1581 VGND.n1921 VGND.n1920 185
R1582 VGND.n73 VGND.n71 185
R1583 VGND.n80 VGND.n77 185
R1584 VGND.n1905 VGND.n1904 185
R1585 VGND.n1902 VGND.n1901 185
R1586 VGND.n1896 VGND.n81 185
R1587 VGND.n1804 VGND.n1803 185
R1588 VGND.n203 VGND.n202 185
R1589 VGND.n209 VGND.n167 185
R1590 VGND.n1806 VGND.n1805 185
R1591 VGND.n1808 VGND.n1807 185
R1592 VGND.n1810 VGND.n1809 185
R1593 VGND.n1812 VGND.n1811 185
R1594 VGND.n1814 VGND.n1813 185
R1595 VGND.n1816 VGND.n1815 185
R1596 VGND.n1818 VGND.n1817 185
R1597 VGND.n1820 VGND.n1819 185
R1598 VGND.n1822 VGND.n1821 185
R1599 VGND.n1824 VGND.n1823 185
R1600 VGND.n1826 VGND.n1825 185
R1601 VGND.n1828 VGND.n1827 185
R1602 VGND.n1830 VGND.n1829 185
R1603 VGND.n1832 VGND.n1831 185
R1604 VGND.n1834 VGND.n1833 185
R1605 VGND.n1836 VGND.n1835 185
R1606 VGND.n1837 VGND.n186 185
R1607 VGND.t42 VGND.n186 185
R1608 VGND.n1839 VGND.n1838 185
R1609 VGND.n1841 VGND.n1840 185
R1610 VGND.n1843 VGND.n1842 185
R1611 VGND.n1845 VGND.n1844 185
R1612 VGND.n1847 VGND.n1846 185
R1613 VGND.n1849 VGND.n1848 185
R1614 VGND.n1851 VGND.n1850 185
R1615 VGND.n1853 VGND.n1852 185
R1616 VGND.n1855 VGND.n1854 185
R1617 VGND.n1856 VGND.n187 185
R1618 VGND.n1869 VGND.n1868 185
R1619 VGND.n166 VGND.n164 185
R1620 VGND.n171 VGND.n157 185
R1621 VGND.n170 VGND.n156 185
R1622 VGND.n191 VGND.n188 185
R1623 VGND.n1866 VGND.n1865 185
R1624 VGND.t42 VGND.n1866 185
R1625 VGND.n1422 VGND.n1421 185
R1626 VGND.n1423 VGND.n333 185
R1627 VGND.n1425 VGND.n1424 185
R1628 VGND.n1427 VGND.n332 185
R1629 VGND.n1430 VGND.n1429 185
R1630 VGND.n1431 VGND.n331 185
R1631 VGND.n1433 VGND.n1432 185
R1632 VGND.n1435 VGND.n330 185
R1633 VGND.n1437 VGND.n1436 185
R1634 VGND.n1403 VGND.n338 185
R1635 VGND.n1406 VGND.n1405 185
R1636 VGND.n1407 VGND.n337 185
R1637 VGND.n1409 VGND.n1408 185
R1638 VGND.n1411 VGND.n336 185
R1639 VGND.n1414 VGND.n1413 185
R1640 VGND.n1415 VGND.n335 185
R1641 VGND.n1417 VGND.n1416 185
R1642 VGND.n1419 VGND.n334 185
R1643 VGND.n1387 VGND.n1386 185
R1644 VGND.n1389 VGND.n343 185
R1645 VGND.n1391 VGND.n1390 185
R1646 VGND.n1392 VGND.n342 185
R1647 VGND.n1394 VGND.n1393 185
R1648 VGND.n1396 VGND.n340 185
R1649 VGND.n1398 VGND.n1397 185
R1650 VGND.n1399 VGND.n339 185
R1651 VGND.n1401 VGND.n1400 185
R1652 VGND.n742 VGND.n345 185
R1653 VGND.n737 VGND.n736 185
R1654 VGND.n734 VGND.n732 185
R1655 VGND.n727 VGND.n320 185
R1656 VGND.n1459 VGND.n1458 185
R1657 VGND.n1456 VGND.n1455 185
R1658 VGND.n1454 VGND.n311 185
R1659 VGND.n1452 VGND.n310 185
R1660 VGND.n1451 VGND.n1450 185
R1661 VGND.n1859 VGND.n194 184.113
R1662 VGND.n1782 VGND.n1660 178.589
R1663 VGND.n1862 VGND.t23 177.335
R1664 VGND.n1632 VGND.n233 175.546
R1665 VGND.n1636 VGND.n1634 175.546
R1666 VGND.n1644 VGND.n228 175.546
R1667 VGND.n1650 VGND.n1646 175.546
R1668 VGND.n1648 VGND.n1647 175.546
R1669 VGND.n576 VGND.n572 175.546
R1670 VGND.n577 VGND.n576 175.546
R1671 VGND.n581 VGND.n577 175.546
R1672 VGND.n582 VGND.n581 175.546
R1673 VGND.n585 VGND.n582 175.546
R1674 VGND.n586 VGND.n585 175.546
R1675 VGND.n587 VGND.n586 175.546
R1676 VGND.n588 VGND.n587 175.546
R1677 VGND.n592 VGND.n588 175.546
R1678 VGND.n593 VGND.n592 175.546
R1679 VGND.n1447 VGND.n1446 175.546
R1680 VGND.n1464 VGND.n1463 175.546
R1681 VGND.n1461 VGND.n315 175.546
R1682 VGND.n724 VGND.n723 175.546
R1683 VGND.n745 VGND.n744 175.546
R1684 VGND.n556 VGND.n555 175.546
R1685 VGND.n555 VGND.n518 175.546
R1686 VGND.n551 VGND.n518 175.546
R1687 VGND.n551 VGND.n523 175.546
R1688 VGND.n545 VGND.n523 175.546
R1689 VGND.n545 VGND.n544 175.546
R1690 VGND.n544 VGND.n543 175.546
R1691 VGND.n543 VGND.n527 175.546
R1692 VGND.n539 VGND.n527 175.546
R1693 VGND.n539 VGND.n533 175.546
R1694 VGND.n533 VGND.n323 175.546
R1695 VGND.n877 VGND.n560 175.546
R1696 VGND.n873 VGND.n560 175.546
R1697 VGND.n873 VGND.n562 175.546
R1698 VGND.n869 VGND.n562 175.546
R1699 VGND.n869 VGND.n563 175.546
R1700 VGND.n865 VGND.n563 175.546
R1701 VGND.n865 VGND.n564 175.546
R1702 VGND.n861 VGND.n564 175.546
R1703 VGND.n861 VGND.n567 175.546
R1704 VGND.n857 VGND.n567 175.546
R1705 VGND.n857 VGND.n570 175.546
R1706 VGND.n774 VGND.n575 175.546
R1707 VGND.n770 VGND.n575 175.546
R1708 VGND.n770 VGND.n579 175.546
R1709 VGND.n766 VGND.n579 175.546
R1710 VGND.n766 VGND.n764 175.546
R1711 VGND.n764 VGND.n763 175.546
R1712 VGND.n763 VGND.n584 175.546
R1713 VGND.n759 VGND.n584 175.546
R1714 VGND.n759 VGND.n590 175.546
R1715 VGND.n755 VGND.n590 175.546
R1716 VGND.n848 VGND.n777 175.546
R1717 VGND.n844 VGND.n777 175.546
R1718 VGND.n844 VGND.n779 175.546
R1719 VGND.n840 VGND.n779 175.546
R1720 VGND.n840 VGND.n781 175.546
R1721 VGND.n836 VGND.n781 175.546
R1722 VGND.n836 VGND.n782 175.546
R1723 VGND.n832 VGND.n782 175.546
R1724 VGND.n832 VGND.n784 175.546
R1725 VGND.n828 VGND.n784 175.546
R1726 VGND.n828 VGND.n787 175.546
R1727 VGND.n819 VGND.n793 175.546
R1728 VGND.n819 VGND.n795 175.546
R1729 VGND.n815 VGND.n795 175.546
R1730 VGND.n815 VGND.n812 175.546
R1731 VGND.n812 VGND.n811 175.546
R1732 VGND.n811 VGND.n798 175.546
R1733 VGND.n807 VGND.n798 175.546
R1734 VGND.n807 VGND.n800 175.546
R1735 VGND.n803 VGND.n800 175.546
R1736 VGND.n803 VGND.n360 175.546
R1737 VGND.n1002 VGND.n360 175.546
R1738 VGND.n718 VGND.n717 175.546
R1739 VGND.n715 VGND.n595 175.546
R1740 VGND.n633 VGND.n632 175.546
R1741 VGND.n641 VGND.n640 175.546
R1742 VGND.n650 VGND.n648 175.546
R1743 VGND.n1003 VGND.n359 175.546
R1744 VGND.n1371 VGND.n349 175.546
R1745 VGND.n1371 VGND.n352 175.546
R1746 VGND.n1367 VGND.n352 175.546
R1747 VGND.n1367 VGND.n355 175.546
R1748 VGND.n1362 VGND.n355 175.546
R1749 VGND.n1362 VGND.n1360 175.546
R1750 VGND.n1360 VGND.n1008 175.546
R1751 VGND.n1356 VGND.n1008 175.546
R1752 VGND.n1356 VGND.n1010 175.546
R1753 VGND.n1352 VGND.n1010 175.546
R1754 VGND.n1352 VGND.n1349 175.546
R1755 VGND.n1310 VGND.n277 175.546
R1756 VGND.n1316 VGND.n1315 175.546
R1757 VGND.n1322 VGND.n1321 175.546
R1758 VGND.n1330 VGND.n1327 175.546
R1759 VGND.n1328 VGND.n1020 175.546
R1760 VGND.n1348 VGND.n1346 175.546
R1761 VGND.n1474 VGND.n1473 175.546
R1762 VGND.n1474 VGND.n289 175.546
R1763 VGND.n1480 VGND.n289 175.546
R1764 VGND.n1480 VGND.n285 175.546
R1765 VGND.n1486 VGND.n285 175.546
R1766 VGND.n1487 VGND.n1486 175.546
R1767 VGND.n1487 VGND.n281 175.546
R1768 VGND.n1493 VGND.n281 175.546
R1769 VGND.n1494 VGND.n1493 175.546
R1770 VGND.n1494 VGND.n276 175.546
R1771 VGND.n1500 VGND.n276 175.546
R1772 VGND.n1470 VGND.n294 175.546
R1773 VGND.n598 VGND.n597 175.546
R1774 VGND.n630 VGND.n627 175.546
R1775 VGND.n638 VGND.n623 175.546
R1776 VGND.n646 VGND.n620 175.546
R1777 VGND.n652 VGND.n296 175.546
R1778 VGND.n1438 VGND.n308 175.546
R1779 VGND.n1467 VGND.n309 175.546
R1780 VGND.n318 VGND.n317 175.546
R1781 VGND.n730 VGND.n729 175.546
R1782 VGND.n740 VGND.n739 175.546
R1783 VGND.n37 VGND.n36 175.546
R1784 VGND.n1961 VGND.n36 175.546
R1785 VGND.n1958 VGND.n1957 175.546
R1786 VGND.n1949 VGND.n1948 175.546
R1787 VGND.n1945 VGND.n32 175.546
R1788 VGND.n1974 VGND.n31 175.546
R1789 VGND.n1612 VGND.n1611 175.546
R1790 VGND.n1614 VGND.n1605 175.546
R1791 VGND.n1515 VGND.n1514 175.546
R1792 VGND.n1517 VGND.n1513 175.546
R1793 VGND.n1535 VGND.n271 175.546
R1794 VGND.n1476 VGND.n291 175.546
R1795 VGND.n1477 VGND.n1476 175.546
R1796 VGND.n1477 VGND.n287 175.546
R1797 VGND.n1483 VGND.n287 175.546
R1798 VGND.n1484 VGND.n1483 175.546
R1799 VGND.n1484 VGND.n283 175.546
R1800 VGND.n1490 VGND.n283 175.546
R1801 VGND.n1490 VGND.n279 175.546
R1802 VGND.n1496 VGND.n279 175.546
R1803 VGND.n1497 VGND.n1496 175.546
R1804 VGND.n1497 VGND.n272 175.546
R1805 VGND.n1230 VGND.n1033 175.546
R1806 VGND.n1040 VGND.n1039 175.546
R1807 VGND.n1046 VGND.n1042 175.546
R1808 VGND.n1049 VGND.n1048 175.546
R1809 VGND.n1055 VGND.n1051 175.546
R1810 VGND.n1313 VGND.n1312 175.546
R1811 VGND.n1319 VGND.n1318 175.546
R1812 VGND.n1325 VGND.n1324 175.546
R1813 VGND.n1334 VGND.n1333 175.546
R1814 VGND.n1336 VGND.n1015 175.546
R1815 VGND.n1082 VGND.n1075 175.546
R1816 VGND.n1085 VGND.n1084 175.546
R1817 VGND.n1090 VGND.n1088 175.546
R1818 VGND.n1094 VGND.n1070 175.546
R1819 VGND.n1098 VGND.n1096 175.546
R1820 VGND.n1185 VGND.n1068 175.546
R1821 VGND.n1203 VGND.n1202 175.546
R1822 VGND.n1200 VGND.n1062 175.546
R1823 VGND.n1196 VGND.n1195 175.546
R1824 VGND.n1192 VGND.n1191 175.546
R1825 VGND.n1189 VGND.n1066 175.546
R1826 VGND.n1630 VGND.n1628 175.546
R1827 VGND.n1638 VGND.n230 175.546
R1828 VGND.n1642 VGND.n1640 175.546
R1829 VGND.n1652 VGND.n226 175.546
R1830 VGND.n1655 VGND.n1654 175.546
R1831 VGND.n1621 VGND.n236 175.546
R1832 VGND.n1602 VGND.n247 175.546
R1833 VGND.n1600 VGND.n248 175.546
R1834 VGND.n1525 VGND.n1507 175.546
R1835 VGND.n1528 VGND.n1527 175.546
R1836 VGND.n1228 VGND.n1227 175.546
R1837 VGND.n1225 VGND.n1037 175.546
R1838 VGND.n1221 VGND.n1220 175.546
R1839 VGND.n1218 VGND.n1045 175.546
R1840 VGND.n1214 VGND.n1213 175.546
R1841 VGND.n1775 VGND.n1759 175.546
R1842 VGND.n1771 VGND.n1769 175.546
R1843 VGND.n1767 VGND.n1761 175.546
R1844 VGND.n1763 VGND.n220 175.546
R1845 VGND.n1883 VGND.n1882 175.546
R1846 VGND.n1882 VGND.n153 175.546
R1847 VGND.n1748 VGND.n1746 175.546
R1848 VGND.n1752 VGND.n1750 175.546
R1849 VGND.n1756 VGND.n1743 175.546
R1850 VGND.n1778 VGND.n1758 175.546
R1851 VGND.n1894 VGND.n1889 175.546
R1852 VGND.n1892 VGND.n1891 175.546
R1853 VGND.n1912 VGND.n76 175.546
R1854 VGND.n1914 VGND.n75 175.546
R1855 VGND.n1933 VGND.n64 175.546
R1856 VGND.n1931 VGND.n26 175.546
R1857 VGND.n1967 VGND.n1966 175.546
R1858 VGND.n1964 VGND.n44 175.546
R1859 VGND.n1954 VGND.n49 175.546
R1860 VGND.n1952 VGND.n50 175.546
R1861 VGND.n1943 VGND.n1942 175.546
R1862 VGND.n83 VGND.n56 175.546
R1863 VGND.n1899 VGND.n1898 175.546
R1864 VGND.n1909 VGND.n1908 175.546
R1865 VGND.n1918 VGND.n1917 175.546
R1866 VGND.n1936 VGND.n61 175.546
R1867 VGND.n1939 VGND.n53 175.546
R1868 VGND.n932 VGND.n931 175.546
R1869 VGND.n931 VGND.n489 175.546
R1870 VGND.n916 VGND.n915 175.546
R1871 VGND.n920 VGND.n919 175.546
R1872 VGND.n924 VGND.n923 175.546
R1873 VGND.n929 VGND.n494 175.546
R1874 VGND.n940 VGND.n939 175.546
R1875 VGND.n973 VGND.n392 175.546
R1876 VGND.n971 VGND.n393 175.546
R1877 VGND.n427 VGND.n425 175.546
R1878 VGND.n443 VGND.n420 175.546
R1879 VGND.n445 VGND.n327 175.546
R1880 VGND.n519 VGND.n513 175.546
R1881 VGND.n520 VGND.n519 175.546
R1882 VGND.n521 VGND.n520 175.546
R1883 VGND.n548 VGND.n521 175.546
R1884 VGND.n548 VGND.n547 175.546
R1885 VGND.n547 VGND.n525 175.546
R1886 VGND.n529 VGND.n525 175.546
R1887 VGND.n530 VGND.n529 175.546
R1888 VGND.n531 VGND.n530 175.546
R1889 VGND.n536 VGND.n531 175.546
R1890 VGND.n536 VGND.n535 175.546
R1891 VGND.n980 VGND.n385 175.546
R1892 VGND.n968 VGND.n397 175.546
R1893 VGND.n966 VGND.n398 175.546
R1894 VGND.n435 VGND.n434 175.546
R1895 VGND.n432 VGND.n431 175.546
R1896 VGND.n997 VGND.n995 175.546
R1897 VGND.n992 VGND.n991 175.546
R1898 VGND.n989 VGND.n381 175.546
R1899 VGND.n985 VGND.n983 175.546
R1900 VGND.n502 VGND.n501 175.546
R1901 VGND.n902 VGND.n502 175.546
R1902 VGND.n902 VGND.n503 175.546
R1903 VGND.n898 VGND.n503 175.546
R1904 VGND.n898 VGND.n506 175.546
R1905 VGND.n894 VGND.n506 175.546
R1906 VGND.n894 VGND.n507 175.546
R1907 VGND.n890 VGND.n507 175.546
R1908 VGND.n890 VGND.n509 175.546
R1909 VGND.n886 VGND.n509 175.546
R1910 VGND.n886 VGND.n512 175.546
R1911 VGND.n205 VGND.t44 175.25
R1912 VGND.n1799 VGND.n1798 175.25
R1913 VGND.t0 VGND.n783 167.392
R1914 VGND.n1859 VGND.n192 165.702
R1915 VGND.n1863 VGND.n192 165.702
R1916 VGND.n1863 VGND.n158 165.702
R1917 VGND.n1875 VGND.n158 165.702
R1918 VGND.n1875 VGND.n159 165.702
R1919 VGND.n1871 VGND.n159 165.702
R1920 VGND.n1786 VGND.n221 165.702
R1921 VGND.n1782 VGND.n221 165.702
R1922 VGND.n483 VGND.n416 163.333
R1923 VGND.n1712 VGND.n1710 163.333
R1924 VGND.n1160 VGND.n1123 163.333
R1925 VGND.n1282 VGND.n1280 163.333
R1926 VGND.n692 VGND.n691 163.333
R1927 VGND.n1573 VGND.n266 163.333
R1928 VGND.n132 VGND.n130 163.333
R1929 VGND.n1421 VGND.n1419 163.333
R1930 VGND.n1871 VGND.n162 157.373
R1931 VGND.t22 VGND.n1860 156.472
R1932 VGND.n1206 VGND.n1059 156.35
R1933 VGND.t5 VGND.n892 153.043
R1934 VGND.n377 VGND.n376 152.643
R1935 VGND.n378 VGND.n377 152.643
R1936 VGND.n996 VGND.n378 152.643
R1937 VGND.n1054 VGND.n199 151.66
R1938 VGND.n1842 VGND.n1841 150
R1939 VGND.n1846 VGND.n1845 150
R1940 VGND.n1850 VGND.n1849 150
R1941 VGND.n1854 VGND.n1853 150
R1942 VGND.n1838 VGND.n186 150
R1943 VGND.n1835 VGND.n186 150
R1944 VGND.n1833 VGND.n1832 150
R1945 VGND.n1829 VGND.n1828 150
R1946 VGND.n1825 VGND.n1824 150
R1947 VGND.n1821 VGND.n1820 150
R1948 VGND.n1817 VGND.n1816 150
R1949 VGND.n1813 VGND.n1812 150
R1950 VGND.n1809 VGND.n1808 150
R1951 VGND.n1866 VGND.n188 150
R1952 VGND.n171 VGND.n170 150
R1953 VGND.n1868 VGND.n166 150
R1954 VGND.n202 VGND.n167 150
R1955 VGND.n481 VGND.n480 150
R1956 VGND.n477 VGND.n476 150
R1957 VGND.n473 VGND.n472 150
R1958 VGND.n469 VGND.n468 150
R1959 VGND.n465 VGND.n464 150
R1960 VGND.n461 VGND.n460 150
R1961 VGND.n457 VGND.n456 150
R1962 VGND.n453 VGND.n452 150
R1963 VGND.n977 VGND.n976 150
R1964 VGND.n961 VGND.n960 150
R1965 VGND.n963 VGND.n401 150
R1966 VGND.n440 VGND.n439 150
R1967 VGND.n958 VGND.n417 150
R1968 VGND.n954 VGND.n953 150
R1969 VGND.n950 VGND.n949 150
R1970 VGND.n946 VGND.n945 150
R1971 VGND.n1708 VGND.n1671 150
R1972 VGND.n1704 VGND.n1702 150
R1973 VGND.n1700 VGND.n1673 150
R1974 VGND.n1696 VGND.n1694 150
R1975 VGND.n1692 VGND.n1675 150
R1976 VGND.n1688 VGND.n1687 150
R1977 VGND.n1685 VGND.n1678 150
R1978 VGND.n1681 VGND.n1680 150
R1979 VGND.n1716 VGND.n1669 150
R1980 VGND.n1720 VGND.n1718 150
R1981 VGND.n1724 VGND.n1667 150
R1982 VGND.n1727 VGND.n1726 150
R1983 VGND.n1158 VGND.n1157 150
R1984 VGND.n1154 VGND.n1153 150
R1985 VGND.n1150 VGND.n1149 150
R1986 VGND.n1146 VGND.n1145 150
R1987 VGND.n1142 VGND.n1141 150
R1988 VGND.n1138 VGND.n1137 150
R1989 VGND.n1134 VGND.n1133 150
R1990 VGND.n1130 VGND.n1129 150
R1991 VGND.n1182 VGND.n1181 150
R1992 VGND.n1179 VGND.n1124 150
R1993 VGND.n1175 VGND.n1174 150
R1994 VGND.n1170 VGND.n1169 150
R1995 VGND.n1166 VGND.n1165 150
R1996 VGND.n1278 VGND.n1241 150
R1997 VGND.n1274 VGND.n1272 150
R1998 VGND.n1270 VGND.n1243 150
R1999 VGND.n1266 VGND.n1264 150
R2000 VGND.n1262 VGND.n1245 150
R2001 VGND.n1258 VGND.n1257 150
R2002 VGND.n1255 VGND.n1248 150
R2003 VGND.n1251 VGND.n1250 150
R2004 VGND.n1305 VGND.n1304 150
R2005 VGND.n1302 VGND.n1301 150
R2006 VGND.n1299 VGND.n1298 150
R2007 VGND.n1339 VGND.n1018 150
R2008 VGND.n1286 VGND.n1239 150
R2009 VGND.n1290 VGND.n1288 150
R2010 VGND.n1294 VGND.n1237 150
R2011 VGND.n1307 VGND.n1296 150
R2012 VGND.n688 VGND.n687 150
R2013 VGND.n684 VGND.n683 150
R2014 VGND.n680 VGND.n679 150
R2015 VGND.n676 VGND.n675 150
R2016 VGND.n672 VGND.n671 150
R2017 VGND.n668 VGND.n667 150
R2018 VGND.n664 VGND.n663 150
R2019 VGND.n660 VGND.n659 150
R2020 VGND.n712 VGND.n600 150
R2021 VGND.n625 VGND.n601 150
R2022 VGND.n636 VGND.n635 150
R2023 VGND.n644 VGND.n643 150
R2024 VGND.n696 VGND.n695 150
R2025 VGND.n700 VGND.n699 150
R2026 VGND.n704 VGND.n703 150
R2027 VGND.n709 VGND.n618 150
R2028 VGND.n1571 VGND.n1570 150
R2029 VGND.n1567 VGND.n1566 150
R2030 VGND.n1563 VGND.n1562 150
R2031 VGND.n1559 VGND.n1558 150
R2032 VGND.n1555 VGND.n1554 150
R2033 VGND.n1551 VGND.n1550 150
R2034 VGND.n1547 VGND.n1546 150
R2035 VGND.n1543 VGND.n1542 150
R2036 VGND.n1618 VGND.n1617 150
R2037 VGND.n1595 VGND.n1593 150
R2038 VGND.n1597 VGND.n251 150
R2039 VGND.n1522 VGND.n1521 150
R2040 VGND.n1591 VGND.n267 150
R2041 VGND.n1587 VGND.n1586 150
R2042 VGND.n1583 VGND.n1582 150
R2043 VGND.n1579 VGND.n1578 150
R2044 VGND.n128 VGND.n91 150
R2045 VGND.n124 VGND.n122 150
R2046 VGND.n120 VGND.n93 150
R2047 VGND.n116 VGND.n114 150
R2048 VGND.n112 VGND.n95 150
R2049 VGND.n108 VGND.n107 150
R2050 VGND.n105 VGND.n98 150
R2051 VGND.n101 VGND.n100 150
R2052 VGND.n1902 VGND.n81 150
R2053 VGND.n1904 VGND.n80 150
R2054 VGND.n1921 VGND.n71 150
R2055 VGND.n1924 VGND.n1923 150
R2056 VGND.n136 VGND.n89 150
R2057 VGND.n140 VGND.n138 150
R2058 VGND.n144 VGND.n87 150
R2059 VGND.n148 VGND.n146 150
R2060 VGND.n1417 VGND.n335 150
R2061 VGND.n1413 VGND.n1411 150
R2062 VGND.n1409 VGND.n337 150
R2063 VGND.n1405 VGND.n1403 150
R2064 VGND.n1401 VGND.n339 150
R2065 VGND.n1397 VGND.n1396 150
R2066 VGND.n1394 VGND.n342 150
R2067 VGND.n1390 VGND.n1389 150
R2068 VGND.n1452 VGND.n1451 150
R2069 VGND.n1456 VGND.n1454 150
R2070 VGND.n1458 VGND.n320 150
R2071 VGND.n736 VGND.n734 150
R2072 VGND.n1425 VGND.n333 150
R2073 VGND.n1429 VGND.n1427 150
R2074 VGND.n1433 VGND.n331 150
R2075 VGND.n1436 VGND.n1435 150
R2076 VGND.n1787 VGND.n220 149.952
R2077 VGND.n855 VGND.t2 148.262
R2078 VGND.n207 VGND.n198 140.714
R2079 VGND.n1801 VGND.n198 140.714
R2080 VGND.n1801 VGND.n199 140.714
R2081 VGND.n565 VGND.t3 133.913
R2082 VGND.n0 VGND.n43 214.905
R2083 VGND.n1729 VGND.n1728 127.963
R2084 VGND.n1203 VGND.n201 126.844
R2085 VGND.n1978 VGND.n27 126.782
R2086 VGND.n853 VGND.n572 126.782
R2087 VGND.n824 VGND.n793 126.782
R2088 VGND.n1375 VGND.n349 126.782
R2089 VGND.n1382 VGND.n291 126.782
R2090 VGND.n1075 VGND.n23 126.782
R2091 VGND.n1035 VGND.n22 126.782
R2092 VGND.n1377 VGND.n1376 126.782
R2093 VGND.n882 VGND.n513 126.782
R2094 VGND.n207 VGND.n204 125.079
R2095 VGND.n556 VGND.n516 124.832
R2096 VGND.n775 VGND.n774 124.832
R2097 VGND.n1473 VGND.n1471 124.832
R2098 VGND.n1970 VGND.n38 124.832
R2099 VGND.n1233 VGND.n1232 124.832
R2100 VGND.n1626 VGND.n1624 124.832
R2101 VGND.n1885 VGND.n85 124.832
R2102 VGND.n937 VGND.n935 124.832
R2103 VGND.n375 VGND.n372 124.832
R2104 VGND.n790 VGND.n6 117.001
R2105 VGND.n791 VGND.n790 117.001
R2106 VGND.n1981 VGND.t12 116.677
R2107 VGND.t1 VGND.n842 114.784
R2108 VGND.t16 VGND.t17 114.27
R2109 VGND.n893 VGND.t34 112.391
R2110 VGND.n864 VGND.t34 112.391
R2111 VGND.n835 VGND.t34 112.391
R2112 VGND.n788 VGND.t18 108.858
R2113 VGND.n1730 VGND.n1729 106.733
R2114 VGND.n1732 VGND.n1731 106.733
R2115 VGND.n1734 VGND.n1733 106.733
R2116 VGND.n1736 VGND.n1735 106.733
R2117 VGND.n1118 VGND.n1105 106.733
R2118 VGND.n1117 VGND.n1104 106.733
R2119 VGND.n1115 VGND.n1103 106.733
R2120 VGND.n1115 VGND.n1102 106.733
R2121 VGND.n1117 VGND.n1103 106.733
R2122 VGND.n1118 VGND.n1104 106.733
R2123 VGND.n1735 VGND.n1734 106.733
R2124 VGND.n1733 VGND.n1732 106.733
R2125 VGND.n1731 VGND.n1730 106.733
R2126 VGND.t34 VGND.n505 102.826
R2127 VGND.t34 VGND.n565 102.826
R2128 VGND.t34 VGND.n780 102.826
R2129 VGND.n843 VGND.t1 100.436
R2130 VGND.t41 VGND.n1765 98.0565
R2131 VGND.t41 VGND.n1872 98.0565
R2132 VGND.n1194 VGND.t41 98.0565
R2133 VGND.n1766 VGND.t41 89.7113
R2134 VGND.n1197 VGND.t41 89.7113
R2135 VGND.n1985 VGND.n1984 83.8569
R2136 VGND.n1985 VGND.n7 83.5719
R2137 VGND.n788 VGND.n7 83.5719
R2138 VGND.n1797 VGND.n1796 83.5719
R2139 VGND.n1798 VGND.n1797 83.5719
R2140 VGND.n870 VGND.t3 81.3049
R2141 VGND.t2 VGND.n854 81.3049
R2142 VGND.t24 VGND.t41 79.2798
R2143 VGND.n1789 VGND.n219 78.8207
R2144 VGND.n233 VGND.n232 76.3222
R2145 VGND.n1634 VGND.n1633 76.3222
R2146 VGND.n1635 VGND.n228 76.3222
R2147 VGND.n1646 VGND.n1645 76.3222
R2148 VGND.n1649 VGND.n1648 76.3222
R2149 VGND.n1659 VGND.n223 76.3222
R2150 VGND.n749 VGND.n748 76.3222
R2151 VGND.n1445 VGND.n1444 76.3222
R2152 VGND.n1464 VGND.n312 76.3222
R2153 VGND.n1462 VGND.n1461 76.3222
R2154 VGND.n724 VGND.n722 76.3222
R2155 VGND.n744 VGND.n720 76.3222
R2156 VGND.n747 VGND.n746 76.3222
R2157 VGND.n755 VGND.n754 76.3222
R2158 VGND.n716 VGND.n715 76.3222
R2159 VGND.n632 VGND.n628 76.3222
R2160 VGND.n640 VGND.n624 76.3222
R2161 VGND.n648 VGND.n621 76.3222
R2162 VGND.n649 VGND.n359 76.3222
R2163 VGND.n1315 VGND.n1031 76.3222
R2164 VGND.n1321 VGND.n1027 76.3222
R2165 VGND.n1327 VGND.n1023 76.3222
R2166 VGND.n1329 VGND.n1328 76.3222
R2167 VGND.n1346 VGND.n1013 76.3222
R2168 VGND.n597 VGND.n298 76.3222
R2169 VGND.n630 VGND.n299 76.3222
R2170 VGND.n638 VGND.n300 76.3222
R2171 VGND.n646 VGND.n301 76.3222
R2172 VGND.n652 VGND.n302 76.3222
R2173 VGND.n620 VGND.n302 76.3222
R2174 VGND.n623 VGND.n301 76.3222
R2175 VGND.n627 VGND.n300 76.3222
R2176 VGND.n598 VGND.n299 76.3222
R2177 VGND.n298 VGND.n294 76.3222
R2178 VGND.n650 VGND.n649 76.3222
R2179 VGND.n641 VGND.n621 76.3222
R2180 VGND.n633 VGND.n624 76.3222
R2181 VGND.n628 VGND.n595 76.3222
R2182 VGND.n717 VGND.n716 76.3222
R2183 VGND.n1020 VGND.n1013 76.3222
R2184 VGND.n1330 VGND.n1329 76.3222
R2185 VGND.n1322 VGND.n1023 76.3222
R2186 VGND.n1316 VGND.n1027 76.3222
R2187 VGND.n1310 VGND.n1031 76.3222
R2188 VGND.n328 VGND.n304 76.3222
R2189 VGND.n1468 VGND.n1467 76.3222
R2190 VGND.n317 VGND.n307 76.3222
R2191 VGND.n729 VGND.n306 76.3222
R2192 VGND.n739 VGND.n305 76.3222
R2193 VGND.n1383 VGND.n297 76.3222
R2194 VGND.n1971 VGND.n1970 76.3222
R2195 VGND.n1961 VGND.n33 76.3222
R2196 VGND.n1957 VGND.n34 76.3222
R2197 VGND.n1949 VGND.n35 76.3222
R2198 VGND.n1973 VGND.n32 76.3222
R2199 VGND.n1610 VGND.n1609 76.3222
R2200 VGND.n1613 VGND.n1612 76.3222
R2201 VGND.n1605 VGND.n243 76.3222
R2202 VGND.n1516 VGND.n1515 76.3222
R2203 VGND.n1513 VGND.n1512 76.3222
R2204 VGND.n1534 VGND.n1533 76.3222
R2205 VGND.n1535 VGND.n1534 76.3222
R2206 VGND.n1512 VGND.n271 76.3222
R2207 VGND.n1517 VGND.n1516 76.3222
R2208 VGND.n1514 VGND.n243 76.3222
R2209 VGND.n1614 VGND.n1613 76.3222
R2210 VGND.n1611 VGND.n1610 76.3222
R2211 VGND.n749 VGND.n593 76.3222
R2212 VGND.n754 VGND.n719 76.3222
R2213 VGND.n1232 VGND.n1231 76.3222
R2214 VGND.n1038 VGND.n1033 76.3222
R2215 VGND.n1041 VGND.n1040 76.3222
R2216 VGND.n1047 VGND.n1046 76.3222
R2217 VGND.n1050 VGND.n1049 76.3222
R2218 VGND.n1056 VGND.n1055 76.3222
R2219 VGND.n1312 VGND.n1235 76.3222
R2220 VGND.n1318 VGND.n1029 76.3222
R2221 VGND.n1324 VGND.n1025 76.3222
R2222 VGND.n1333 VGND.n1021 76.3222
R2223 VGND.n1336 VGND.n1335 76.3222
R2224 VGND.n1077 VGND.n1076 76.3222
R2225 VGND.n1076 VGND.n1015 76.3222
R2226 VGND.n1335 VGND.n1334 76.3222
R2227 VGND.n1325 VGND.n1021 76.3222
R2228 VGND.n1319 VGND.n1025 76.3222
R2229 VGND.n1313 VGND.n1029 76.3222
R2230 VGND.n1084 VGND.n1083 76.3222
R2231 VGND.n1088 VGND.n1073 76.3222
R2232 VGND.n1089 VGND.n1070 76.3222
R2233 VGND.n1096 VGND.n1095 76.3222
R2234 VGND.n1097 VGND.n1068 76.3222
R2235 VGND.n1201 VGND.n1200 76.3222
R2236 VGND.n1196 VGND.n1063 76.3222
R2237 VGND.n1192 VGND.n1064 76.3222
R2238 VGND.n1190 VGND.n1189 76.3222
R2239 VGND.n1186 VGND.n1067 76.3222
R2240 VGND.n1098 VGND.n1097 76.3222
R2241 VGND.n1095 VGND.n1094 76.3222
R2242 VGND.n1090 VGND.n1089 76.3222
R2243 VGND.n1085 VGND.n1073 76.3222
R2244 VGND.n1083 VGND.n1082 76.3222
R2245 VGND.n1067 VGND.n1066 76.3222
R2246 VGND.n1191 VGND.n1190 76.3222
R2247 VGND.n1195 VGND.n1064 76.3222
R2248 VGND.n1063 VGND.n1062 76.3222
R2249 VGND.n1202 VGND.n1201 76.3222
R2250 VGND.n1231 VGND.n1230 76.3222
R2251 VGND.n1039 VGND.n1038 76.3222
R2252 VGND.n1042 VGND.n1041 76.3222
R2253 VGND.n1048 VGND.n1047 76.3222
R2254 VGND.n1051 VGND.n1050 76.3222
R2255 VGND.n1057 VGND.n1056 76.3222
R2256 VGND.n1235 VGND.n1234 76.3222
R2257 VGND.n1627 VGND.n1626 76.3222
R2258 VGND.n1630 VGND.n1629 76.3222
R2259 VGND.n1639 VGND.n1638 76.3222
R2260 VGND.n1642 VGND.n1641 76.3222
R2261 VGND.n1653 VGND.n1652 76.3222
R2262 VGND.n1656 VGND.n1655 76.3222
R2263 VGND.n1622 VGND.n1621 76.3222
R2264 VGND.n246 VGND.n236 76.3222
R2265 VGND.n1602 VGND.n1601 76.3222
R2266 VGND.n1506 VGND.n248 76.3222
R2267 VGND.n1526 VGND.n1525 76.3222
R2268 VGND.n1529 VGND.n1528 76.3222
R2269 VGND.n247 VGND.n246 76.3222
R2270 VGND.n1601 VGND.n1600 76.3222
R2271 VGND.n1507 VGND.n1506 76.3222
R2272 VGND.n1527 VGND.n1526 76.3222
R2273 VGND.n1530 VGND.n1529 76.3222
R2274 VGND.n1228 VGND.n1036 76.3222
R2275 VGND.n1226 VGND.n1225 76.3222
R2276 VGND.n1221 VGND.n1044 76.3222
R2277 VGND.n1219 VGND.n1218 76.3222
R2278 VGND.n1214 VGND.n1053 76.3222
R2279 VGND.n1212 VGND.n1211 76.3222
R2280 VGND.n1213 VGND.n1212 76.3222
R2281 VGND.n1053 VGND.n1045 76.3222
R2282 VGND.n1220 VGND.n1219 76.3222
R2283 VGND.n1044 VGND.n1037 76.3222
R2284 VGND.n1227 VGND.n1226 76.3222
R2285 VGND.n1036 VGND.n1035 76.3222
R2286 VGND.n1777 VGND.n1776 76.3222
R2287 VGND.n1770 VGND.n1759 76.3222
R2288 VGND.n1769 VGND.n1768 76.3222
R2289 VGND.n1762 VGND.n1761 76.3222
R2290 VGND.n1885 VGND.n1884 76.3222
R2291 VGND.n1745 VGND.n153 76.3222
R2292 VGND.n1749 VGND.n1748 76.3222
R2293 VGND.n1752 VGND.n1751 76.3222
R2294 VGND.n1757 VGND.n1756 76.3222
R2295 VGND.n1893 VGND.n1892 76.3222
R2296 VGND.n1891 VGND.n1890 76.3222
R2297 VGND.n1913 VGND.n1912 76.3222
R2298 VGND.n75 VGND.n74 76.3222
R2299 VGND.n1933 VGND.n1932 76.3222
R2300 VGND.n1894 VGND.n1893 76.3222
R2301 VGND.n1890 VGND.n76 76.3222
R2302 VGND.n1914 VGND.n1913 76.3222
R2303 VGND.n74 VGND.n64 76.3222
R2304 VGND.n1932 VGND.n1931 76.3222
R2305 VGND.n1967 VGND.n41 76.3222
R2306 VGND.n1965 VGND.n1964 76.3222
R2307 VGND.n49 VGND.n48 76.3222
R2308 VGND.n1953 VGND.n1952 76.3222
R2309 VGND.n1943 VGND.n52 76.3222
R2310 VGND.n1941 VGND.n1940 76.3222
R2311 VGND.n1898 VGND.n57 76.3222
R2312 VGND.n1908 VGND.n58 76.3222
R2313 VGND.n1917 VGND.n59 76.3222
R2314 VGND.n61 VGND.n60 76.3222
R2315 VGND.n1937 VGND.n53 76.3222
R2316 VGND.n1937 VGND.n1936 76.3222
R2317 VGND.n1918 VGND.n60 76.3222
R2318 VGND.n1909 VGND.n59 76.3222
R2319 VGND.n1899 VGND.n58 76.3222
R2320 VGND.n83 VGND.n57 76.3222
R2321 VGND.n935 VGND.n487 76.3222
R2322 VGND.n490 VGND.n489 76.3222
R2323 VGND.n916 VGND.n491 76.3222
R2324 VGND.n920 VGND.n492 76.3222
R2325 VGND.n924 VGND.n493 76.3222
R2326 VGND.n938 VGND.n392 76.3222
R2327 VGND.n972 VGND.n971 76.3222
R2328 VGND.n425 VGND.n424 76.3222
R2329 VGND.n426 VGND.n420 76.3222
R2330 VGND.n445 VGND.n444 76.3222
R2331 VGND.n444 VGND.n443 76.3222
R2332 VGND.n427 VGND.n426 76.3222
R2333 VGND.n424 VGND.n393 76.3222
R2334 VGND.n973 VGND.n972 76.3222
R2335 VGND.n939 VGND.n938 76.3222
R2336 VGND.n981 VGND.n980 76.3222
R2337 VGND.n397 VGND.n396 76.3222
R2338 VGND.n967 VGND.n966 76.3222
R2339 VGND.n435 VGND.n429 76.3222
R2340 VGND.n433 VGND.n432 76.3222
R2341 VGND.n430 VGND.n326 76.3222
R2342 VGND.n431 VGND.n430 76.3222
R2343 VGND.n434 VGND.n433 76.3222
R2344 VGND.n429 VGND.n398 76.3222
R2345 VGND.n968 VGND.n967 76.3222
R2346 VGND.n396 VGND.n385 76.3222
R2347 VGND.n376 VGND.n375 76.3222
R2348 VGND.n995 VGND.n379 76.3222
R2349 VGND.n991 VGND.n990 76.3222
R2350 VGND.n984 VGND.n381 76.3222
R2351 VGND.n997 VGND.n996 76.3222
R2352 VGND.n992 VGND.n379 76.3222
R2353 VGND.n990 VGND.n989 76.3222
R2354 VGND.n985 VGND.n984 76.3222
R2355 VGND.n982 VGND.n981 76.3222
R2356 VGND.n932 VGND.n487 76.3222
R2357 VGND.n915 VGND.n490 76.3222
R2358 VGND.n919 VGND.n491 76.3222
R2359 VGND.n923 VGND.n492 76.3222
R2360 VGND.n494 VGND.n493 76.3222
R2361 VGND.n1884 VGND.n1883 76.3222
R2362 VGND.n1746 VGND.n1745 76.3222
R2363 VGND.n1750 VGND.n1749 76.3222
R2364 VGND.n1751 VGND.n1743 76.3222
R2365 VGND.n1758 VGND.n1757 76.3222
R2366 VGND.n1776 VGND.n1775 76.3222
R2367 VGND.n1771 VGND.n1770 76.3222
R2368 VGND.n1768 VGND.n1767 76.3222
R2369 VGND.n1763 VGND.n1762 76.3222
R2370 VGND.n1628 VGND.n1627 76.3222
R2371 VGND.n1629 VGND.n230 76.3222
R2372 VGND.n1640 VGND.n1639 76.3222
R2373 VGND.n1641 VGND.n226 76.3222
R2374 VGND.n1654 VGND.n1653 76.3222
R2375 VGND.n1657 VGND.n1656 76.3222
R2376 VGND.n1647 VGND.n223 76.3222
R2377 VGND.n1650 VGND.n1649 76.3222
R2378 VGND.n1645 VGND.n1644 76.3222
R2379 VGND.n1636 VGND.n1635 76.3222
R2380 VGND.n1633 VGND.n1632 76.3222
R2381 VGND.n232 VGND.n27 76.3222
R2382 VGND.n1623 VGND.n1622 76.3222
R2383 VGND.n1942 VGND.n1941 76.3222
R2384 VGND.n52 VGND.n50 76.3222
R2385 VGND.n1954 VGND.n1953 76.3222
R2386 VGND.n48 VGND.n44 76.3222
R2387 VGND.n1966 VGND.n1965 76.3222
R2388 VGND.n1376 VGND.n41 76.3222
R2389 VGND.n1971 VGND.n37 76.3222
R2390 VGND.n1958 VGND.n33 76.3222
R2391 VGND.n1948 VGND.n34 76.3222
R2392 VGND.n1945 VGND.n35 76.3222
R2393 VGND.n1974 VGND.n1973 76.3222
R2394 VGND.n740 VGND.n297 76.3222
R2395 VGND.n730 VGND.n305 76.3222
R2396 VGND.n318 VGND.n306 76.3222
R2397 VGND.n309 VGND.n307 76.3222
R2398 VGND.n1468 VGND.n308 76.3222
R2399 VGND.n1438 VGND.n304 76.3222
R2400 VGND.n746 VGND.n745 76.3222
R2401 VGND.n723 VGND.n720 76.3222
R2402 VGND.n722 VGND.n315 76.3222
R2403 VGND.n1463 VGND.n1462 76.3222
R2404 VGND.n1447 VGND.n312 76.3222
R2405 VGND.n1446 VGND.n1445 76.3222
R2406 VGND.n1980 VGND.n10 74.8511
R2407 VGND.n977 VGND.n388 74.5978
R2408 VGND.n945 VGND.n388 74.5978
R2409 VGND.n1728 VGND.n1727 74.5978
R2410 VGND.n1182 VGND.n1106 74.5978
R2411 VGND.n1306 VGND.n1305 74.5978
R2412 VGND.n1307 VGND.n1306 74.5978
R2413 VGND.n710 VGND.n600 74.5978
R2414 VGND.n710 VGND.n709 74.5978
R2415 VGND.n1618 VGND.n239 74.5978
R2416 VGND.n1578 VGND.n239 74.5978
R2417 VGND.n1165 VGND.n1106 74.5978
R2418 VGND.n147 VGND.n81 74.5978
R2419 VGND.n148 VGND.n147 74.5978
R2420 VGND.n1451 VGND.n321 74.5978
R2421 VGND.n1436 VGND.n321 74.5978
R2422 VGND.n1980 VGND.n11 72.4409
R2423 VGND.n1980 VGND.n12 72.3223
R2424 VGND.n1980 VGND.n13 70.8051
R2425 VGND.n1789 VGND.n211 70.165
R2426 VGND.n1824 VGND.n178 69.3109
R2427 VGND.n468 VGND.n406 69.3109
R2428 VGND.n465 VGND.n406 69.3109
R2429 VGND.n1694 VGND.n1693 69.3109
R2430 VGND.n1693 VGND.n1692 69.3109
R2431 VGND.n1145 VGND.n1109 69.3109
R2432 VGND.n1264 VGND.n1263 69.3109
R2433 VGND.n1263 VGND.n1262 69.3109
R2434 VGND.n675 VGND.n607 69.3109
R2435 VGND.n672 VGND.n607 69.3109
R2436 VGND.n1558 VGND.n256 69.3109
R2437 VGND.n1555 VGND.n256 69.3109
R2438 VGND.n1142 VGND.n1109 69.3109
R2439 VGND.n114 VGND.n113 69.3109
R2440 VGND.n113 VGND.n112 69.3109
R2441 VGND.n1821 VGND.n178 69.3109
R2442 VGND.n1403 VGND.n1402 69.3109
R2443 VGND.n1402 VGND.n1401 69.3109
R2444 VGND.n789 VGND.t14 67.9611
R2445 VGND.n1001 VGND.t34 67.1761
R2446 VGND.n1350 VGND.t32 67.1761
R2447 VGND.t36 VGND.n959 65.8183
R2448 VGND.t36 VGND.n415 65.8183
R2449 VGND.t36 VGND.n414 65.8183
R2450 VGND.t36 VGND.n413 65.8183
R2451 VGND.t36 VGND.n404 65.8183
R2452 VGND.t36 VGND.n411 65.8183
R2453 VGND.t36 VGND.n402 65.8183
R2454 VGND.t36 VGND.n412 65.8183
R2455 VGND.t36 VGND.n410 65.8183
R2456 VGND.t36 VGND.n409 65.8183
R2457 VGND.t36 VGND.n408 65.8183
R2458 VGND.t36 VGND.n407 65.8183
R2459 VGND.t36 VGND.n405 65.8183
R2460 VGND.t36 VGND.n403 65.8183
R2461 VGND.n962 VGND.t36 65.8183
R2462 VGND.t36 VGND.n389 65.8183
R2463 VGND.n1711 VGND.t43 65.8183
R2464 VGND.n1717 VGND.t43 65.8183
R2465 VGND.n1719 VGND.t43 65.8183
R2466 VGND.n1725 VGND.t43 65.8183
R2467 VGND.n1695 VGND.t43 65.8183
R2468 VGND.n1701 VGND.t43 65.8183
R2469 VGND.n1703 VGND.t43 65.8183
R2470 VGND.n1709 VGND.t43 65.8183
R2471 VGND.t43 VGND.n1665 65.8183
R2472 VGND.n1679 VGND.t43 65.8183
R2473 VGND.n1686 VGND.t43 65.8183
R2474 VGND.n1677 VGND.t43 65.8183
R2475 VGND.n1281 VGND.t37 65.8183
R2476 VGND.n1287 VGND.t37 65.8183
R2477 VGND.n1289 VGND.t37 65.8183
R2478 VGND.n1295 VGND.t37 65.8183
R2479 VGND.n1265 VGND.t37 65.8183
R2480 VGND.n1271 VGND.t37 65.8183
R2481 VGND.n1273 VGND.t37 65.8183
R2482 VGND.n1279 VGND.t37 65.8183
R2483 VGND.t37 VGND.n1017 65.8183
R2484 VGND.n1249 VGND.t37 65.8183
R2485 VGND.n1256 VGND.t37 65.8183
R2486 VGND.n1247 VGND.t37 65.8183
R2487 VGND.n1340 VGND.t37 65.8183
R2488 VGND.n1297 VGND.t37 65.8183
R2489 VGND.n1300 VGND.t37 65.8183
R2490 VGND.n1303 VGND.t37 65.8183
R2491 VGND.t33 VGND.n617 65.8183
R2492 VGND.t33 VGND.n616 65.8183
R2493 VGND.t33 VGND.n615 65.8183
R2494 VGND.t33 VGND.n614 65.8183
R2495 VGND.t33 VGND.n605 65.8183
R2496 VGND.t33 VGND.n612 65.8183
R2497 VGND.t33 VGND.n602 65.8183
R2498 VGND.t33 VGND.n613 65.8183
R2499 VGND.t33 VGND.n611 65.8183
R2500 VGND.t33 VGND.n610 65.8183
R2501 VGND.t33 VGND.n609 65.8183
R2502 VGND.t33 VGND.n608 65.8183
R2503 VGND.t33 VGND.n606 65.8183
R2504 VGND.t33 VGND.n604 65.8183
R2505 VGND.t33 VGND.n603 65.8183
R2506 VGND.n711 VGND.t33 65.8183
R2507 VGND.t31 VGND.n1592 65.8183
R2508 VGND.t31 VGND.n265 65.8183
R2509 VGND.t31 VGND.n264 65.8183
R2510 VGND.t31 VGND.n263 65.8183
R2511 VGND.t31 VGND.n254 65.8183
R2512 VGND.t31 VGND.n261 65.8183
R2513 VGND.t31 VGND.n252 65.8183
R2514 VGND.t31 VGND.n262 65.8183
R2515 VGND.t31 VGND.n260 65.8183
R2516 VGND.t31 VGND.n259 65.8183
R2517 VGND.t31 VGND.n258 65.8183
R2518 VGND.t31 VGND.n257 65.8183
R2519 VGND.t31 VGND.n255 65.8183
R2520 VGND.t31 VGND.n253 65.8183
R2521 VGND.n1596 VGND.t31 65.8183
R2522 VGND.t31 VGND.n240 65.8183
R2523 VGND.t40 VGND.n1180 65.8183
R2524 VGND.t40 VGND.n1122 65.8183
R2525 VGND.t40 VGND.n1121 65.8183
R2526 VGND.t40 VGND.n1120 65.8183
R2527 VGND.t40 VGND.n1108 65.8183
R2528 VGND.t40 VGND.n1116 65.8183
R2529 VGND.t40 VGND.n1107 65.8183
R2530 VGND.t40 VGND.n1119 65.8183
R2531 VGND.t40 VGND.n1113 65.8183
R2532 VGND.t40 VGND.n1112 65.8183
R2533 VGND.t40 VGND.n1111 65.8183
R2534 VGND.t40 VGND.n1110 65.8183
R2535 VGND.n1183 VGND.n1102 65.8183
R2536 VGND.n1183 VGND.n1103 65.8183
R2537 VGND.t40 VGND.n1115 65.8183
R2538 VGND.n1183 VGND.n1104 65.8183
R2539 VGND.t40 VGND.n1117 65.8183
R2540 VGND.n1183 VGND.n1105 65.8183
R2541 VGND.t40 VGND.n1118 65.8183
R2542 VGND.n131 VGND.t38 65.8183
R2543 VGND.n137 VGND.t38 65.8183
R2544 VGND.n139 VGND.t38 65.8183
R2545 VGND.n145 VGND.t38 65.8183
R2546 VGND.n115 VGND.t38 65.8183
R2547 VGND.n121 VGND.t38 65.8183
R2548 VGND.n123 VGND.t38 65.8183
R2549 VGND.n129 VGND.t38 65.8183
R2550 VGND.t38 VGND.n67 65.8183
R2551 VGND.n99 VGND.t38 65.8183
R2552 VGND.n106 VGND.t38 65.8183
R2553 VGND.n97 VGND.t38 65.8183
R2554 VGND.n1925 VGND.t38 65.8183
R2555 VGND.n1922 VGND.t38 65.8183
R2556 VGND.n79 VGND.t38 65.8183
R2557 VGND.n1903 VGND.t38 65.8183
R2558 VGND.n1735 VGND.n1662 65.8183
R2559 VGND.n1736 VGND.t43 65.8183
R2560 VGND.n1733 VGND.n1662 65.8183
R2561 VGND.n1734 VGND.t43 65.8183
R2562 VGND.n1731 VGND.n1662 65.8183
R2563 VGND.n1732 VGND.t43 65.8183
R2564 VGND.n1729 VGND.n1662 65.8183
R2565 VGND.n1730 VGND.t43 65.8183
R2566 VGND.t42 VGND.n173 65.8183
R2567 VGND.t42 VGND.n177 65.8183
R2568 VGND.t42 VGND.n176 65.8183
R2569 VGND.t42 VGND.n175 65.8183
R2570 VGND.t42 VGND.n174 65.8183
R2571 VGND.t42 VGND.n179 65.8183
R2572 VGND.t42 VGND.n180 65.8183
R2573 VGND.t42 VGND.n169 65.8183
R2574 VGND.t42 VGND.n182 65.8183
R2575 VGND.t42 VGND.n183 65.8183
R2576 VGND.t42 VGND.n184 65.8183
R2577 VGND.t42 VGND.n185 65.8183
R2578 VGND.n1867 VGND.t42 65.8183
R2579 VGND.t42 VGND.n172 65.8183
R2580 VGND.t42 VGND.n168 65.8183
R2581 VGND.n1420 VGND.t35 65.8183
R2582 VGND.n1426 VGND.t35 65.8183
R2583 VGND.n1428 VGND.t35 65.8183
R2584 VGND.n1434 VGND.t35 65.8183
R2585 VGND.n1404 VGND.t35 65.8183
R2586 VGND.n1410 VGND.t35 65.8183
R2587 VGND.n1412 VGND.t35 65.8183
R2588 VGND.n1418 VGND.t35 65.8183
R2589 VGND.n1388 VGND.t35 65.8183
R2590 VGND.n344 VGND.t35 65.8183
R2591 VGND.n1395 VGND.t35 65.8183
R2592 VGND.n341 VGND.t35 65.8183
R2593 VGND.n735 VGND.t35 65.8183
R2594 VGND.n733 VGND.t35 65.8183
R2595 VGND.n1457 VGND.t35 65.8183
R2596 VGND.n1453 VGND.t35 65.8183
R2597 VGND.t42 VGND.n181 64.1729
R2598 VGND.n1660 VGND.n1659 62.4163
R2599 VGND.n1059 VGND.n1057 62.4163
R2600 VGND.n1657 VGND.n194 62.4163
R2601 VGND.n1211 VGND.n1054 62.4163
R2602 VGND.n893 VGND.t5 62.1744
R2603 VGND.t34 VGND.n364 58.1503
R2604 VGND.t34 VGND.n367 58.1503
R2605 VGND.n1499 VGND.t32 57.8952
R2606 VGND.t36 VGND.n406 57.8461
R2607 VGND.n1693 VGND.t43 57.8461
R2608 VGND.n1263 VGND.t37 57.8461
R2609 VGND.t33 VGND.n607 57.8461
R2610 VGND.t31 VGND.n256 57.8461
R2611 VGND.t40 VGND.n1109 57.8461
R2612 VGND.n113 VGND.t38 57.8461
R2613 VGND.t42 VGND.n178 57.8461
R2614 VGND.n1402 VGND.t35 57.8461
R2615 VGND.n1841 VGND.n181 56.6572
R2616 VGND.n1838 VGND.n181 56.6572
R2617 VGND.t36 VGND.n388 55.2026
R2618 VGND.n1306 VGND.t37 55.2026
R2619 VGND.t33 VGND.n710 55.2026
R2620 VGND.t31 VGND.n239 55.2026
R2621 VGND.t40 VGND.n1106 55.2026
R2622 VGND.n147 VGND.t38 55.2026
R2623 VGND.n1728 VGND.t43 55.2026
R2624 VGND.n321 VGND.t35 55.2026
R2625 VGND.n908 VGND.n373 53.889
R2626 VGND.n1842 VGND.n182 53.3664
R2627 VGND.n1846 VGND.n183 53.3664
R2628 VGND.n1850 VGND.n184 53.3664
R2629 VGND.n1854 VGND.n185 53.3664
R2630 VGND.n1835 VGND.n169 53.3664
R2631 VGND.n1832 VGND.n180 53.3664
R2632 VGND.n1828 VGND.n179 53.3664
R2633 VGND.n1817 VGND.n174 53.3664
R2634 VGND.n1813 VGND.n175 53.3664
R2635 VGND.n1809 VGND.n176 53.3664
R2636 VGND.n1805 VGND.n177 53.3664
R2637 VGND.n188 VGND.n168 53.3664
R2638 VGND.n172 VGND.n171 53.3664
R2639 VGND.n1868 VGND.n1867 53.3664
R2640 VGND.n202 VGND.n173 53.3664
R2641 VGND.n483 VGND.n412 53.3664
R2642 VGND.n480 VGND.n402 53.3664
R2643 VGND.n476 VGND.n411 53.3664
R2644 VGND.n472 VGND.n404 53.3664
R2645 VGND.n461 VGND.n407 53.3664
R2646 VGND.n457 VGND.n408 53.3664
R2647 VGND.n453 VGND.n409 53.3664
R2648 VGND.n449 VGND.n410 53.3664
R2649 VGND.n976 VGND.n389 53.3664
R2650 VGND.n962 VGND.n961 53.3664
R2651 VGND.n403 VGND.n401 53.3664
R2652 VGND.n440 VGND.n405 53.3664
R2653 VGND.n959 VGND.n958 53.3664
R2654 VGND.n417 VGND.n415 53.3664
R2655 VGND.n953 VGND.n414 53.3664
R2656 VGND.n949 VGND.n413 53.3664
R2657 VGND.n959 VGND.n416 53.3664
R2658 VGND.n954 VGND.n415 53.3664
R2659 VGND.n950 VGND.n414 53.3664
R2660 VGND.n946 VGND.n413 53.3664
R2661 VGND.n469 VGND.n404 53.3664
R2662 VGND.n473 VGND.n411 53.3664
R2663 VGND.n477 VGND.n402 53.3664
R2664 VGND.n481 VGND.n412 53.3664
R2665 VGND.n452 VGND.n410 53.3664
R2666 VGND.n456 VGND.n409 53.3664
R2667 VGND.n460 VGND.n408 53.3664
R2668 VGND.n464 VGND.n407 53.3664
R2669 VGND.n448 VGND.n405 53.3664
R2670 VGND.n439 VGND.n403 53.3664
R2671 VGND.n963 VGND.n962 53.3664
R2672 VGND.n960 VGND.n389 53.3664
R2673 VGND.n1710 VGND.n1709 53.3664
R2674 VGND.n1703 VGND.n1671 53.3664
R2675 VGND.n1702 VGND.n1701 53.3664
R2676 VGND.n1695 VGND.n1673 53.3664
R2677 VGND.n1688 VGND.n1677 53.3664
R2678 VGND.n1686 VGND.n1685 53.3664
R2679 VGND.n1681 VGND.n1679 53.3664
R2680 VGND.n1738 VGND.n1665 53.3664
R2681 VGND.n1711 VGND.n1669 53.3664
R2682 VGND.n1717 VGND.n1716 53.3664
R2683 VGND.n1720 VGND.n1719 53.3664
R2684 VGND.n1725 VGND.n1724 53.3664
R2685 VGND.n1712 VGND.n1711 53.3664
R2686 VGND.n1718 VGND.n1717 53.3664
R2687 VGND.n1719 VGND.n1667 53.3664
R2688 VGND.n1726 VGND.n1725 53.3664
R2689 VGND.n1696 VGND.n1695 53.3664
R2690 VGND.n1701 VGND.n1700 53.3664
R2691 VGND.n1704 VGND.n1703 53.3664
R2692 VGND.n1709 VGND.n1708 53.3664
R2693 VGND.n1680 VGND.n1665 53.3664
R2694 VGND.n1679 VGND.n1678 53.3664
R2695 VGND.n1687 VGND.n1686 53.3664
R2696 VGND.n1677 VGND.n1675 53.3664
R2697 VGND.n1737 VGND.n1736 53.3664
R2698 VGND.n1160 VGND.n1119 53.3664
R2699 VGND.n1157 VGND.n1107 53.3664
R2700 VGND.n1153 VGND.n1116 53.3664
R2701 VGND.n1149 VGND.n1108 53.3664
R2702 VGND.n1138 VGND.n1110 53.3664
R2703 VGND.n1134 VGND.n1111 53.3664
R2704 VGND.n1130 VGND.n1112 53.3664
R2705 VGND.n1126 VGND.n1113 53.3664
R2706 VGND.n1114 VGND.n1102 53.3664
R2707 VGND.n1180 VGND.n1179 53.3664
R2708 VGND.n1124 VGND.n1122 53.3664
R2709 VGND.n1174 VGND.n1121 53.3664
R2710 VGND.n1169 VGND.n1120 53.3664
R2711 VGND.n1280 VGND.n1279 53.3664
R2712 VGND.n1273 VGND.n1241 53.3664
R2713 VGND.n1272 VGND.n1271 53.3664
R2714 VGND.n1265 VGND.n1243 53.3664
R2715 VGND.n1258 VGND.n1247 53.3664
R2716 VGND.n1256 VGND.n1255 53.3664
R2717 VGND.n1251 VGND.n1249 53.3664
R2718 VGND.n1342 VGND.n1017 53.3664
R2719 VGND.n1304 VGND.n1303 53.3664
R2720 VGND.n1301 VGND.n1300 53.3664
R2721 VGND.n1298 VGND.n1297 53.3664
R2722 VGND.n1340 VGND.n1339 53.3664
R2723 VGND.n1281 VGND.n1239 53.3664
R2724 VGND.n1287 VGND.n1286 53.3664
R2725 VGND.n1290 VGND.n1289 53.3664
R2726 VGND.n1295 VGND.n1294 53.3664
R2727 VGND.n1282 VGND.n1281 53.3664
R2728 VGND.n1288 VGND.n1287 53.3664
R2729 VGND.n1289 VGND.n1237 53.3664
R2730 VGND.n1296 VGND.n1295 53.3664
R2731 VGND.n1266 VGND.n1265 53.3664
R2732 VGND.n1271 VGND.n1270 53.3664
R2733 VGND.n1274 VGND.n1273 53.3664
R2734 VGND.n1279 VGND.n1278 53.3664
R2735 VGND.n1250 VGND.n1017 53.3664
R2736 VGND.n1249 VGND.n1248 53.3664
R2737 VGND.n1257 VGND.n1256 53.3664
R2738 VGND.n1247 VGND.n1245 53.3664
R2739 VGND.n1341 VGND.n1340 53.3664
R2740 VGND.n1297 VGND.n1018 53.3664
R2741 VGND.n1300 VGND.n1299 53.3664
R2742 VGND.n1303 VGND.n1302 53.3664
R2743 VGND.n691 VGND.n613 53.3664
R2744 VGND.n687 VGND.n602 53.3664
R2745 VGND.n683 VGND.n612 53.3664
R2746 VGND.n679 VGND.n605 53.3664
R2747 VGND.n668 VGND.n608 53.3664
R2748 VGND.n664 VGND.n609 53.3664
R2749 VGND.n660 VGND.n610 53.3664
R2750 VGND.n656 VGND.n611 53.3664
R2751 VGND.n712 VGND.n711 53.3664
R2752 VGND.n625 VGND.n603 53.3664
R2753 VGND.n635 VGND.n604 53.3664
R2754 VGND.n643 VGND.n606 53.3664
R2755 VGND.n695 VGND.n617 53.3664
R2756 VGND.n696 VGND.n616 53.3664
R2757 VGND.n700 VGND.n615 53.3664
R2758 VGND.n704 VGND.n614 53.3664
R2759 VGND.n692 VGND.n617 53.3664
R2760 VGND.n699 VGND.n616 53.3664
R2761 VGND.n703 VGND.n615 53.3664
R2762 VGND.n618 VGND.n614 53.3664
R2763 VGND.n676 VGND.n605 53.3664
R2764 VGND.n680 VGND.n612 53.3664
R2765 VGND.n684 VGND.n602 53.3664
R2766 VGND.n688 VGND.n613 53.3664
R2767 VGND.n659 VGND.n611 53.3664
R2768 VGND.n663 VGND.n610 53.3664
R2769 VGND.n667 VGND.n609 53.3664
R2770 VGND.n671 VGND.n608 53.3664
R2771 VGND.n655 VGND.n606 53.3664
R2772 VGND.n644 VGND.n604 53.3664
R2773 VGND.n636 VGND.n603 53.3664
R2774 VGND.n711 VGND.n601 53.3664
R2775 VGND.n1573 VGND.n262 53.3664
R2776 VGND.n1570 VGND.n252 53.3664
R2777 VGND.n1566 VGND.n261 53.3664
R2778 VGND.n1562 VGND.n254 53.3664
R2779 VGND.n1551 VGND.n257 53.3664
R2780 VGND.n1547 VGND.n258 53.3664
R2781 VGND.n1543 VGND.n259 53.3664
R2782 VGND.n1539 VGND.n260 53.3664
R2783 VGND.n1617 VGND.n240 53.3664
R2784 VGND.n1596 VGND.n1595 53.3664
R2785 VGND.n253 VGND.n251 53.3664
R2786 VGND.n1522 VGND.n255 53.3664
R2787 VGND.n1592 VGND.n1591 53.3664
R2788 VGND.n267 VGND.n265 53.3664
R2789 VGND.n1586 VGND.n264 53.3664
R2790 VGND.n1582 VGND.n263 53.3664
R2791 VGND.n1592 VGND.n266 53.3664
R2792 VGND.n1587 VGND.n265 53.3664
R2793 VGND.n1583 VGND.n264 53.3664
R2794 VGND.n1579 VGND.n263 53.3664
R2795 VGND.n1559 VGND.n254 53.3664
R2796 VGND.n1563 VGND.n261 53.3664
R2797 VGND.n1567 VGND.n252 53.3664
R2798 VGND.n1571 VGND.n262 53.3664
R2799 VGND.n1542 VGND.n260 53.3664
R2800 VGND.n1546 VGND.n259 53.3664
R2801 VGND.n1550 VGND.n258 53.3664
R2802 VGND.n1554 VGND.n257 53.3664
R2803 VGND.n1538 VGND.n255 53.3664
R2804 VGND.n1521 VGND.n253 53.3664
R2805 VGND.n1597 VGND.n1596 53.3664
R2806 VGND.n1593 VGND.n240 53.3664
R2807 VGND.n1180 VGND.n1123 53.3664
R2808 VGND.n1175 VGND.n1122 53.3664
R2809 VGND.n1170 VGND.n1121 53.3664
R2810 VGND.n1166 VGND.n1120 53.3664
R2811 VGND.n1146 VGND.n1108 53.3664
R2812 VGND.n1150 VGND.n1116 53.3664
R2813 VGND.n1154 VGND.n1107 53.3664
R2814 VGND.n1158 VGND.n1119 53.3664
R2815 VGND.n1129 VGND.n1113 53.3664
R2816 VGND.n1133 VGND.n1112 53.3664
R2817 VGND.n1137 VGND.n1111 53.3664
R2818 VGND.n1141 VGND.n1110 53.3664
R2819 VGND.n1181 VGND.n1105 53.3664
R2820 VGND.n130 VGND.n129 53.3664
R2821 VGND.n123 VGND.n91 53.3664
R2822 VGND.n122 VGND.n121 53.3664
R2823 VGND.n115 VGND.n93 53.3664
R2824 VGND.n108 VGND.n97 53.3664
R2825 VGND.n106 VGND.n105 53.3664
R2826 VGND.n101 VGND.n99 53.3664
R2827 VGND.n1927 VGND.n67 53.3664
R2828 VGND.n1903 VGND.n1902 53.3664
R2829 VGND.n80 VGND.n79 53.3664
R2830 VGND.n1922 VGND.n1921 53.3664
R2831 VGND.n1925 VGND.n1924 53.3664
R2832 VGND.n131 VGND.n89 53.3664
R2833 VGND.n137 VGND.n136 53.3664
R2834 VGND.n140 VGND.n139 53.3664
R2835 VGND.n145 VGND.n144 53.3664
R2836 VGND.n132 VGND.n131 53.3664
R2837 VGND.n138 VGND.n137 53.3664
R2838 VGND.n139 VGND.n87 53.3664
R2839 VGND.n146 VGND.n145 53.3664
R2840 VGND.n116 VGND.n115 53.3664
R2841 VGND.n121 VGND.n120 53.3664
R2842 VGND.n124 VGND.n123 53.3664
R2843 VGND.n129 VGND.n128 53.3664
R2844 VGND.n100 VGND.n67 53.3664
R2845 VGND.n99 VGND.n98 53.3664
R2846 VGND.n107 VGND.n106 53.3664
R2847 VGND.n97 VGND.n95 53.3664
R2848 VGND.n1926 VGND.n1925 53.3664
R2849 VGND.n1923 VGND.n1922 53.3664
R2850 VGND.n79 VGND.n71 53.3664
R2851 VGND.n1904 VGND.n1903 53.3664
R2852 VGND.n1804 VGND.n173 53.3664
R2853 VGND.n1867 VGND.n167 53.3664
R2854 VGND.n1808 VGND.n177 53.3664
R2855 VGND.n1812 VGND.n176 53.3664
R2856 VGND.n1816 VGND.n175 53.3664
R2857 VGND.n1820 VGND.n174 53.3664
R2858 VGND.n1825 VGND.n179 53.3664
R2859 VGND.n1829 VGND.n180 53.3664
R2860 VGND.n1833 VGND.n169 53.3664
R2861 VGND.n1845 VGND.n182 53.3664
R2862 VGND.n1849 VGND.n183 53.3664
R2863 VGND.n1853 VGND.n184 53.3664
R2864 VGND.n187 VGND.n185 53.3664
R2865 VGND.n172 VGND.n166 53.3664
R2866 VGND.n170 VGND.n168 53.3664
R2867 VGND.n1419 VGND.n1418 53.3664
R2868 VGND.n1412 VGND.n335 53.3664
R2869 VGND.n1411 VGND.n1410 53.3664
R2870 VGND.n1404 VGND.n337 53.3664
R2871 VGND.n1397 VGND.n341 53.3664
R2872 VGND.n1395 VGND.n1394 53.3664
R2873 VGND.n1390 VGND.n344 53.3664
R2874 VGND.n1388 VGND.n1387 53.3664
R2875 VGND.n1453 VGND.n1452 53.3664
R2876 VGND.n1457 VGND.n1456 53.3664
R2877 VGND.n733 VGND.n320 53.3664
R2878 VGND.n736 VGND.n735 53.3664
R2879 VGND.n1420 VGND.n333 53.3664
R2880 VGND.n1426 VGND.n1425 53.3664
R2881 VGND.n1429 VGND.n1428 53.3664
R2882 VGND.n1434 VGND.n1433 53.3664
R2883 VGND.n1421 VGND.n1420 53.3664
R2884 VGND.n1427 VGND.n1426 53.3664
R2885 VGND.n1428 VGND.n331 53.3664
R2886 VGND.n1435 VGND.n1434 53.3664
R2887 VGND.n1405 VGND.n1404 53.3664
R2888 VGND.n1410 VGND.n1409 53.3664
R2889 VGND.n1413 VGND.n1412 53.3664
R2890 VGND.n1418 VGND.n1417 53.3664
R2891 VGND.n1389 VGND.n1388 53.3664
R2892 VGND.n344 VGND.n342 53.3664
R2893 VGND.n1396 VGND.n1395 53.3664
R2894 VGND.n341 VGND.n339 53.3664
R2895 VGND.n735 VGND.n345 53.3664
R2896 VGND.n734 VGND.n733 53.3664
R2897 VGND.n1458 VGND.n1457 53.3664
R2898 VGND.n1454 VGND.n1453 53.3664
R2899 VGND.t26 VGND.n193 52.1579
R2900 VGND.n827 VGND.t0 47.8266
R2901 VGND.n789 VGND.t16 46.31
R2902 VGND.n1789 VGND.n1788 41.7862
R2903 VGND.n1788 VGND.n193 41.7862
R2904 VGND.n213 VGND.t46 41.0016
R2905 VGND.n1792 VGND.t21 41.0016
R2906 VGND.n214 VGND.t45 40.8142
R2907 VGND.n1793 VGND.t20 40.8142
R2908 VGND.n216 VGND.t30 40.8142
R2909 VGND.n3 VGND.t15 40.8142
R2910 VGND.t34 VGND.n11 38.9687
R2911 VGND.n1938 VGND.t32 34.3913
R2912 VGND.n214 VGND 33.275
R2913 VGND.n1793 VGND 33.275
R2914 VGND.n216 VGND 33.275
R2915 VGND.n3 VGND 33.275
R2916 VGND.n213 VGND 33.0976
R2917 VGND.n1792 VGND 33.0976
R2918 VGND.n1206 VGND.n201 32.8338
R2919 VGND.n1861 VGND.t22 31.295
R2920 VGND.n558 VGND.t4 31.0875
R2921 VGND.n1178 VGND.n1125 26.7912
R2922 VGND.n1178 VGND.n1177 26.7912
R2923 VGND.n1177 VGND.n1176 26.7912
R2924 VGND.n1176 VGND.n1173 26.7912
R2925 VGND.n1171 VGND.n1168 26.7912
R2926 VGND.n1168 VGND.n1167 26.7912
R2927 VGND.n1167 VGND.n1164 26.7912
R2928 VGND.t41 VGND.n1979 26.2993
R2929 VGND.n1796 VGND.n211 24.1535
R2930 VGND.n1172 VGND.n1171 24.1121
R2931 VGND.n467 VGND.n466 23.6449
R2932 VGND.n1691 VGND.n1674 23.6449
R2933 VGND.n1261 VGND.n1244 23.6449
R2934 VGND.n674 VGND.n673 23.6449
R2935 VGND.n1557 VGND.n1556 23.6449
R2936 VGND.n1144 VGND.n1143 23.6449
R2937 VGND.n111 VGND.n94 23.6449
R2938 VGND.n1823 VGND.n1822 23.6449
R2939 VGND.n1400 VGND.n338 23.6449
R2940 VGND.n1787 VGND.n1786 22.094
R2941 VGND.n9 VGND 21.2467
R2942 VGND.n1381 VGND.t39 21.2419
R2943 VGND.n1798 VGND.t27 20.8635
R2944 VGND.n1071 VGND.n212 19.8537
R2945 VGND.n1164 VGND.n1163 19.2212
R2946 VGND.n1796 VGND.n212 18.7553
R2947 VGND.n485 VGND.n484 17.4227
R2948 VGND.n1713 VGND.n1670 17.4227
R2949 VGND.n1283 VGND.n1240 17.4227
R2950 VGND.n693 VGND.n690 17.4227
R2951 VGND.n1575 VGND.n1574 17.4227
R2952 VGND.n133 VGND.n90 17.4227
R2953 VGND.n1840 VGND.n1839 17.4227
R2954 VGND.n1422 VGND.n334 17.4227
R2955 VGND.n957 VGND.n485 16.0005
R2956 VGND.n957 VGND.n956 16.0005
R2957 VGND.n956 VGND.n955 16.0005
R2958 VGND.n955 VGND.n952 16.0005
R2959 VGND.n952 VGND.n951 16.0005
R2960 VGND.n951 VGND.n948 16.0005
R2961 VGND.n948 VGND.n947 16.0005
R2962 VGND.n947 VGND.n944 16.0005
R2963 VGND.n484 VGND.n482 16.0005
R2964 VGND.n482 VGND.n479 16.0005
R2965 VGND.n479 VGND.n478 16.0005
R2966 VGND.n478 VGND.n475 16.0005
R2967 VGND.n475 VGND.n474 16.0005
R2968 VGND.n471 VGND.n470 16.0005
R2969 VGND.n470 VGND.n467 16.0005
R2970 VGND.n466 VGND.n463 16.0005
R2971 VGND.n463 VGND.n462 16.0005
R2972 VGND.n462 VGND.n459 16.0005
R2973 VGND.n459 VGND.n458 16.0005
R2974 VGND.n458 VGND.n455 16.0005
R2975 VGND.n455 VGND.n454 16.0005
R2976 VGND.n454 VGND.n451 16.0005
R2977 VGND.n451 VGND.n450 16.0005
R2978 VGND.n1714 VGND.n1713 16.0005
R2979 VGND.n1715 VGND.n1714 16.0005
R2980 VGND.n1715 VGND.n1668 16.0005
R2981 VGND.n1721 VGND.n1668 16.0005
R2982 VGND.n1722 VGND.n1721 16.0005
R2983 VGND.n1723 VGND.n1722 16.0005
R2984 VGND.n1723 VGND.n1666 16.0005
R2985 VGND.n1666 VGND.n1663 16.0005
R2986 VGND.n1707 VGND.n1670 16.0005
R2987 VGND.n1707 VGND.n1706 16.0005
R2988 VGND.n1706 VGND.n1705 16.0005
R2989 VGND.n1705 VGND.n1672 16.0005
R2990 VGND.n1699 VGND.n1672 16.0005
R2991 VGND.n1698 VGND.n1697 16.0005
R2992 VGND.n1697 VGND.n1674 16.0005
R2993 VGND.n1691 VGND.n1690 16.0005
R2994 VGND.n1690 VGND.n1689 16.0005
R2995 VGND.n1689 VGND.n1676 16.0005
R2996 VGND.n1684 VGND.n1676 16.0005
R2997 VGND.n1684 VGND.n1683 16.0005
R2998 VGND.n1683 VGND.n1682 16.0005
R2999 VGND.n1682 VGND.n1664 16.0005
R3000 VGND.n1739 VGND.n1664 16.0005
R3001 VGND.n1284 VGND.n1283 16.0005
R3002 VGND.n1285 VGND.n1284 16.0005
R3003 VGND.n1285 VGND.n1238 16.0005
R3004 VGND.n1291 VGND.n1238 16.0005
R3005 VGND.n1292 VGND.n1291 16.0005
R3006 VGND.n1293 VGND.n1292 16.0005
R3007 VGND.n1293 VGND.n1236 16.0005
R3008 VGND.n1308 VGND.n1236 16.0005
R3009 VGND.n1277 VGND.n1240 16.0005
R3010 VGND.n1277 VGND.n1276 16.0005
R3011 VGND.n1276 VGND.n1275 16.0005
R3012 VGND.n1275 VGND.n1242 16.0005
R3013 VGND.n1269 VGND.n1242 16.0005
R3014 VGND.n1268 VGND.n1267 16.0005
R3015 VGND.n1267 VGND.n1244 16.0005
R3016 VGND.n1261 VGND.n1260 16.0005
R3017 VGND.n1260 VGND.n1259 16.0005
R3018 VGND.n1259 VGND.n1246 16.0005
R3019 VGND.n1254 VGND.n1246 16.0005
R3020 VGND.n1254 VGND.n1253 16.0005
R3021 VGND.n1253 VGND.n1252 16.0005
R3022 VGND.n1252 VGND.n1016 16.0005
R3023 VGND.n1343 VGND.n1016 16.0005
R3024 VGND.n694 VGND.n693 16.0005
R3025 VGND.n697 VGND.n694 16.0005
R3026 VGND.n698 VGND.n697 16.0005
R3027 VGND.n701 VGND.n698 16.0005
R3028 VGND.n702 VGND.n701 16.0005
R3029 VGND.n705 VGND.n702 16.0005
R3030 VGND.n706 VGND.n705 16.0005
R3031 VGND.n708 VGND.n706 16.0005
R3032 VGND.n690 VGND.n689 16.0005
R3033 VGND.n689 VGND.n686 16.0005
R3034 VGND.n686 VGND.n685 16.0005
R3035 VGND.n685 VGND.n682 16.0005
R3036 VGND.n682 VGND.n681 16.0005
R3037 VGND.n678 VGND.n677 16.0005
R3038 VGND.n677 VGND.n674 16.0005
R3039 VGND.n673 VGND.n670 16.0005
R3040 VGND.n670 VGND.n669 16.0005
R3041 VGND.n669 VGND.n666 16.0005
R3042 VGND.n666 VGND.n665 16.0005
R3043 VGND.n665 VGND.n662 16.0005
R3044 VGND.n662 VGND.n661 16.0005
R3045 VGND.n661 VGND.n658 16.0005
R3046 VGND.n658 VGND.n657 16.0005
R3047 VGND.n1590 VGND.n1575 16.0005
R3048 VGND.n1590 VGND.n1589 16.0005
R3049 VGND.n1589 VGND.n1588 16.0005
R3050 VGND.n1588 VGND.n1585 16.0005
R3051 VGND.n1585 VGND.n1584 16.0005
R3052 VGND.n1584 VGND.n1581 16.0005
R3053 VGND.n1581 VGND.n1580 16.0005
R3054 VGND.n1580 VGND.n1577 16.0005
R3055 VGND.n1574 VGND.n1572 16.0005
R3056 VGND.n1572 VGND.n1569 16.0005
R3057 VGND.n1569 VGND.n1568 16.0005
R3058 VGND.n1568 VGND.n1565 16.0005
R3059 VGND.n1565 VGND.n1564 16.0005
R3060 VGND.n1561 VGND.n1560 16.0005
R3061 VGND.n1560 VGND.n1557 16.0005
R3062 VGND.n1556 VGND.n1553 16.0005
R3063 VGND.n1553 VGND.n1552 16.0005
R3064 VGND.n1552 VGND.n1549 16.0005
R3065 VGND.n1549 VGND.n1548 16.0005
R3066 VGND.n1548 VGND.n1545 16.0005
R3067 VGND.n1545 VGND.n1544 16.0005
R3068 VGND.n1544 VGND.n1541 16.0005
R3069 VGND.n1541 VGND.n1540 16.0005
R3070 VGND.n1161 VGND.n1159 16.0005
R3071 VGND.n1159 VGND.n1156 16.0005
R3072 VGND.n1156 VGND.n1155 16.0005
R3073 VGND.n1155 VGND.n1152 16.0005
R3074 VGND.n1152 VGND.n1151 16.0005
R3075 VGND.n1148 VGND.n1147 16.0005
R3076 VGND.n1147 VGND.n1144 16.0005
R3077 VGND.n1143 VGND.n1140 16.0005
R3078 VGND.n1140 VGND.n1139 16.0005
R3079 VGND.n1139 VGND.n1136 16.0005
R3080 VGND.n1136 VGND.n1135 16.0005
R3081 VGND.n1135 VGND.n1132 16.0005
R3082 VGND.n1132 VGND.n1131 16.0005
R3083 VGND.n1131 VGND.n1128 16.0005
R3084 VGND.n1128 VGND.n1127 16.0005
R3085 VGND.n134 VGND.n133 16.0005
R3086 VGND.n135 VGND.n134 16.0005
R3087 VGND.n135 VGND.n88 16.0005
R3088 VGND.n141 VGND.n88 16.0005
R3089 VGND.n142 VGND.n141 16.0005
R3090 VGND.n143 VGND.n142 16.0005
R3091 VGND.n143 VGND.n86 16.0005
R3092 VGND.n149 VGND.n86 16.0005
R3093 VGND.n127 VGND.n90 16.0005
R3094 VGND.n127 VGND.n126 16.0005
R3095 VGND.n126 VGND.n125 16.0005
R3096 VGND.n125 VGND.n92 16.0005
R3097 VGND.n119 VGND.n92 16.0005
R3098 VGND.n118 VGND.n117 16.0005
R3099 VGND.n117 VGND.n94 16.0005
R3100 VGND.n111 VGND.n110 16.0005
R3101 VGND.n110 VGND.n109 16.0005
R3102 VGND.n109 VGND.n96 16.0005
R3103 VGND.n104 VGND.n96 16.0005
R3104 VGND.n104 VGND.n103 16.0005
R3105 VGND.n103 VGND.n102 16.0005
R3106 VGND.n102 VGND.n66 16.0005
R3107 VGND.n1928 VGND.n66 16.0005
R3108 VGND.n1822 VGND.n1819 16.0005
R3109 VGND.n1819 VGND.n1818 16.0005
R3110 VGND.n1818 VGND.n1815 16.0005
R3111 VGND.n1815 VGND.n1814 16.0005
R3112 VGND.n1814 VGND.n1811 16.0005
R3113 VGND.n1811 VGND.n1810 16.0005
R3114 VGND.n1810 VGND.n1807 16.0005
R3115 VGND.n1807 VGND.n1806 16.0005
R3116 VGND.n1839 VGND.n1837 16.0005
R3117 VGND.n1837 VGND.n1836 16.0005
R3118 VGND.n1836 VGND.n1834 16.0005
R3119 VGND.n1834 VGND.n1831 16.0005
R3120 VGND.n1831 VGND.n1830 16.0005
R3121 VGND.n1827 VGND.n1826 16.0005
R3122 VGND.n1826 VGND.n1823 16.0005
R3123 VGND.n1843 VGND.n1840 16.0005
R3124 VGND.n1844 VGND.n1843 16.0005
R3125 VGND.n1847 VGND.n1844 16.0005
R3126 VGND.n1848 VGND.n1847 16.0005
R3127 VGND.n1851 VGND.n1848 16.0005
R3128 VGND.n1852 VGND.n1851 16.0005
R3129 VGND.n1855 VGND.n1852 16.0005
R3130 VGND.n1856 VGND.n1855 16.0005
R3131 VGND.n1423 VGND.n1422 16.0005
R3132 VGND.n1424 VGND.n1423 16.0005
R3133 VGND.n1424 VGND.n332 16.0005
R3134 VGND.n1430 VGND.n332 16.0005
R3135 VGND.n1431 VGND.n1430 16.0005
R3136 VGND.n1432 VGND.n1431 16.0005
R3137 VGND.n1432 VGND.n330 16.0005
R3138 VGND.n1437 VGND.n330 16.0005
R3139 VGND.n1416 VGND.n334 16.0005
R3140 VGND.n1416 VGND.n1415 16.0005
R3141 VGND.n1415 VGND.n1414 16.0005
R3142 VGND.n1414 VGND.n336 16.0005
R3143 VGND.n1408 VGND.n336 16.0005
R3144 VGND.n1407 VGND.n1406 16.0005
R3145 VGND.n1406 VGND.n338 16.0005
R3146 VGND.n1400 VGND.n1399 16.0005
R3147 VGND.n1399 VGND.n1398 16.0005
R3148 VGND.n1398 VGND.n340 16.0005
R3149 VGND.n1393 VGND.n340 16.0005
R3150 VGND.n1393 VGND.n1392 16.0005
R3151 VGND.n1392 VGND.n1391 16.0005
R3152 VGND.n1391 VGND.n343 16.0005
R3153 VGND.n1386 VGND.n343 16.0005
R3154 VGND.n204 VGND.n162 15.6354
R3155 VGND.n1740 VGND.n1739 14.592
R3156 VGND.n450 VGND.n325 13.6894
R3157 VGND.n1344 VGND.n1343 13.6894
R3158 VGND.n657 VGND.n357 13.6894
R3159 VGND.n1540 VGND.n268 13.6894
R3160 VGND.n1929 VGND.n1928 13.6894
R3161 VGND.n1806 VGND.n196 13.6894
R3162 VGND.n1386 VGND.n1385 13.6894
R3163 VGND.n471 VGND 12.9783
R3164 VGND VGND.n1698 12.9783
R3165 VGND VGND.n1268 12.9783
R3166 VGND.n678 VGND 12.9783
R3167 VGND.n1561 VGND 12.9783
R3168 VGND.n1148 VGND 12.9783
R3169 VGND VGND.n118 12.9783
R3170 VGND.n1827 VGND 12.9783
R3171 VGND VGND.n1407 12.9783
R3172 VGND.n1800 VGND.t44 12.5183
R3173 VGND.n1984 VGND.n1983 12.0113
R3174 VGND.n1162 VGND.n1125 11.9075
R3175 VGND.n1986 VGND.n1985 11.8659
R3176 VGND.n1979 VGND.n12 11.6327
R3177 VGND.t23 VGND.n160 10.432
R3178 VGND.n1873 VGND.t24 10.432
R3179 VGND.n944 VGND.n943 10.3116
R3180 VGND.n1309 VGND.n1308 10.3116
R3181 VGND.n708 VGND.n707 10.3116
R3182 VGND.n1577 VGND.n1576 10.3116
R3183 VGND.n150 VGND.n149 10.3116
R3184 VGND.n1857 VGND.n1856 10.3116
R3185 VGND.n1440 VGND.n1437 10.3116
R3186 VGND.n1163 VGND.n1058 9.96943
R3187 VGND.n1071 VGND.n1061 9.73351
R3188 VGND.n906 VGND.n8 9.72642
R3189 VGND.n909 VGND.n908 9.3005
R3190 VGND.n1987 VGND.n1986 9.3005
R3191 VGND.n1780 VGND.n1661 7.79537
R3192 VGND.n1162 VGND.n1161 7.64494
R3193 VGND.n942 VGND.n941 7.61523
R3194 VGND.n1005 VGND.n350 7.51963
R3195 VGND.n1888 VGND.n151 6.96898
R3196 VGND.n1078 VGND.n1006 6.64531
R3197 VGND.n1469 VGND.n303 6.57521
R3198 VGND.n1783 VGND.t29 6.25939
R3199 VGND.n1209 VGND.n1207 6.19405
R3200 VGND.t17 VGND.n788 6.01472
R3201 VGND.n1441 VGND.n329 5.90608
R3202 VGND.n215 VGND.n214 5.13944
R3203 VGND VGND.n1793 5.13191
R3204 VGND.n1469 VGND.n10 5.05797
R3205 VGND.n1381 VGND.n303 5.05797
R3206 VGND.n1938 VGND.n13 5.05797
R3207 VGND.n852 VGND.n573 4.88894
R3208 VGND.n881 VGND.n514 4.88894
R3209 VGND.n822 VGND.n498 4.87323
R3210 VGND.n1982 VGND.n9 4.79768
R3211 VGND.n1504 VGND.n1503 4.04261
R3212 VGND.n1502 VGND.n1501 4.04261
R3213 VGND.n934 VGND.n933 4.04261
R3214 VGND.n933 VGND.n488 4.04261
R3215 VGND.n495 VGND.n488 4.04261
R3216 VGND.n917 VGND.n914 4.04261
R3217 VGND.n918 VGND.n917 4.04261
R3218 VGND.n921 VGND.n918 4.04261
R3219 VGND.n922 VGND.n921 4.04261
R3220 VGND.n925 VGND.n922 4.04261
R3221 VGND.n926 VGND.n925 4.04261
R3222 VGND.n1977 VGND.n1976 3.98871
R3223 VGND.n1606 VGND.n29 3.98871
R3224 VGND.n994 VGND.n993 3.98666
R3225 VGND.n993 VGND.n380 3.98666
R3226 VGND.n988 VGND.n987 3.98666
R3227 VGND.n1886 VGND.n152 3.98666
R3228 VGND.n1881 VGND.n152 3.98666
R3229 VGND.n1881 VGND.n1880 3.98666
R3230 VGND.n1747 VGND.n154 3.98666
R3231 VGND.n1747 VGND.n1744 3.98666
R3232 VGND.n1753 VGND.n1744 3.98666
R3233 VGND.n1754 VGND.n1753 3.98666
R3234 VGND.n1755 VGND.n1754 3.98666
R3235 VGND.n1755 VGND.n1742 3.98666
R3236 VGND.n987 VGND.n986 3.97863
R3237 VGND.n934 VGND.n486 3.83497
R3238 VGND.n821 VGND.n820 3.81507
R3239 VGND.n820 VGND.n794 3.81507
R3240 VGND.n814 VGND.n794 3.81507
R3241 VGND.n814 VGND.n813 3.81507
R3242 VGND.n810 VGND.n809 3.81507
R3243 VGND.n809 VGND.n808 3.81507
R3244 VGND.n808 VGND.n799 3.81507
R3245 VGND.n802 VGND.n799 3.81507
R3246 VGND.n1373 VGND.n1372 3.81507
R3247 VGND.n1372 VGND.n351 3.81507
R3248 VGND.n1366 VGND.n351 3.81507
R3249 VGND.n1366 VGND.n1365 3.81507
R3250 VGND.n1363 VGND.n1007 3.81507
R3251 VGND.n1011 VGND.n1007 3.81507
R3252 VGND.n1355 VGND.n1011 3.81507
R3253 VGND.n1355 VGND.n1354 3.81507
R3254 VGND.n1354 VGND.n1353 3.81507
R3255 VGND.n1081 VGND.n1080 3.81507
R3256 VGND.n1081 VGND.n1074 3.81507
R3257 VGND.n1086 VGND.n1074 3.81507
R3258 VGND.n1087 VGND.n1086 3.81507
R3259 VGND.n1092 VGND.n1091 3.81507
R3260 VGND.n1093 VGND.n1092 3.81507
R3261 VGND.n1093 VGND.n1069 3.81507
R3262 VGND.n1099 VGND.n1069 3.81507
R3263 VGND.n1100 VGND.n1099 3.81507
R3264 VGND.n802 VGND.n801 3.80766
R3265 VGND.n1887 VGND.n1886 3.80391
R3266 VGND.n927 VGND.n151 3.77815
R3267 VGND.n823 VGND.n822 3.74595
R3268 VGND.n907 VGND.n906 3.70851
R3269 VGND.n908 VGND.n907 3.67298
R3270 VGND.n751 VGND.n750 3.65764
R3271 VGND.n753 VGND.n752 3.65764
R3272 VGND.n1374 VGND.n1373 3.6372
R3273 VGND.n1080 VGND.n1079 3.6372
R3274 VGND.n1988 VGND.n1987 3.63197
R3275 VGND.n928 VGND.n926 3.62257
R3276 VGND.n823 VGND.n786 3.49141
R3277 VGND.n1353 VGND.n1012 3.36297
R3278 VGND.n876 VGND.n875 3.27323
R3279 VGND.n875 VGND.n874 3.27323
R3280 VGND.n874 VGND.n561 3.27323
R3281 VGND.n868 VGND.n561 3.27323
R3282 VGND.n868 VGND.n867 3.27323
R3283 VGND.n867 VGND.n866 3.27323
R3284 VGND.n860 VGND.n568 3.27323
R3285 VGND.n860 VGND.n859 3.27323
R3286 VGND.n859 VGND.n858 3.27323
R3287 VGND.n858 VGND.n569 3.27323
R3288 VGND.n847 VGND.n846 3.27323
R3289 VGND.n846 VGND.n845 3.27323
R3290 VGND.n845 VGND.n778 3.27323
R3291 VGND.n839 VGND.n778 3.27323
R3292 VGND.n839 VGND.n838 3.27323
R3293 VGND.n838 VGND.n837 3.27323
R3294 VGND.n831 VGND.n785 3.27323
R3295 VGND.n831 VGND.n830 3.27323
R3296 VGND.n830 VGND.n829 3.27323
R3297 VGND.n829 VGND.n786 3.27323
R3298 VGND.n499 VGND.n374 3.27323
R3299 VGND.n903 VGND.n500 3.27323
R3300 VGND.n897 VGND.n500 3.27323
R3301 VGND.n897 VGND.n896 3.27323
R3302 VGND.n896 VGND.n895 3.27323
R3303 VGND.n889 VGND.n510 3.27323
R3304 VGND.n889 VGND.n888 3.27323
R3305 VGND.n888 VGND.n887 3.27323
R3306 VGND.n887 VGND.n511 3.27323
R3307 VGND.n986 VGND.n383 3.26396
R3308 VGND.n1347 VGND.n1006 3.25296
R3309 VGND.n801 VGND.n358 3.14804
R3310 VGND.n928 VGND.n927 3.0813
R3311 VGND.n1005 VGND.n1004 3.0781
R3312 VGND.n1365 VGND.n1364 3.05216
R3313 VGND.n384 VGND.n383 3.04639
R3314 VGND.n1858 VGND.n195 3.02595
R3315 VGND.n474 VGND 3.02272
R3316 VGND.n1699 VGND 3.02272
R3317 VGND.n1269 VGND 3.02272
R3318 VGND.n681 VGND 3.02272
R3319 VGND.n1564 VGND 3.02272
R3320 VGND.n1151 VGND 3.02272
R3321 VGND.n119 VGND 3.02272
R3322 VGND.n1830 VGND 3.02272
R3323 VGND.n1408 VGND 3.02272
R3324 VGND.n942 VGND.n384 3.01013
R3325 VGND.n1004 VGND.n358 2.9382
R3326 VGND.n1347 VGND.n1012 2.9382
R3327 VGND.n1790 VGND.n218 2.92738
R3328 VGND.n568 VGND 2.90959
R3329 VGND.n785 VGND 2.90959
R3330 VGND.n510 VGND 2.90959
R3331 VGND.n852 VGND.n574 2.89497
R3332 VGND.n580 VGND.n574 2.89497
R3333 VGND.n769 VGND.n580 2.89497
R3334 VGND.n769 VGND.n768 2.89497
R3335 VGND.n768 VGND.n767 2.89497
R3336 VGND.n767 VGND.n583 2.89497
R3337 VGND.n762 VGND.n583 2.89497
R3338 VGND.n762 VGND.n761 2.89497
R3339 VGND.n761 VGND.n760 2.89497
R3340 VGND.n760 VGND.n589 2.89497
R3341 VGND.n1229 VGND.n274 2.89497
R3342 VGND.n1229 VGND.n1034 2.89497
R3343 VGND.n1224 VGND.n1034 2.89497
R3344 VGND.n1224 VGND.n1223 2.89497
R3345 VGND.n1223 VGND.n1222 2.89497
R3346 VGND.n1222 VGND.n1043 2.89497
R3347 VGND.n1217 VGND.n1043 2.89497
R3348 VGND.n1217 VGND.n1216 2.89497
R3349 VGND.n1216 VGND.n1215 2.89497
R3350 VGND.n1215 VGND.n1052 2.89497
R3351 VGND.n1210 VGND.n1052 2.89497
R3352 VGND.n881 VGND.n515 2.89497
R3353 VGND.n554 VGND.n515 2.89497
R3354 VGND.n554 VGND.n553 2.89497
R3355 VGND.n553 VGND.n552 2.89497
R3356 VGND.n552 VGND.n522 2.89497
R3357 VGND.n546 VGND.n522 2.89497
R3358 VGND.n546 VGND.n526 2.89497
R3359 VGND.n528 VGND.n526 2.89497
R3360 VGND.n534 VGND.n528 2.89497
R3361 VGND.n538 VGND.n534 2.89497
R3362 VGND.n1625 VGND.n234 2.89497
R3363 VGND.n1631 VGND.n234 2.89497
R3364 VGND.n1631 VGND.n231 2.89497
R3365 VGND.n1637 VGND.n231 2.89497
R3366 VGND.n1637 VGND.n229 2.89497
R3367 VGND.n1643 VGND.n229 2.89497
R3368 VGND.n1643 VGND.n227 2.89497
R3369 VGND.n1651 VGND.n227 2.89497
R3370 VGND.n1651 VGND.n225 2.89497
R3371 VGND.n225 VGND.n224 2.89497
R3372 VGND.n1658 VGND.n224 2.89497
R3373 VGND.n538 VGND.n537 2.89028
R3374 VGND.n1475 VGND.n292 2.8805
R3375 VGND.n1475 VGND.n288 2.8805
R3376 VGND.n1481 VGND.n288 2.8805
R3377 VGND.n1482 VGND.n1481 2.8805
R3378 VGND.n1482 VGND.n284 2.8805
R3379 VGND.n1488 VGND.n284 2.8805
R3380 VGND.n1489 VGND.n1488 2.8805
R3381 VGND.n1489 VGND.n280 2.8805
R3382 VGND.n1495 VGND.n280 2.8805
R3383 VGND.n1495 VGND.n273 2.8805
R3384 VGND.n1879 VGND.n154 2.87939
R3385 VGND.n752 VGND.n589 2.86281
R3386 VGND.n822 VGND.n821 2.79785
R3387 VGND.n1781 VGND.n195 2.79323
R3388 VGND.n914 VGND.n913 2.74015
R3389 VGND.n1501 VGND.n275 2.72218
R3390 VGND.n1173 VGND.n1172 2.67957
R3391 VGND.n1608 VGND.n1607 2.66829
R3392 VGND.n1865 VGND.n189 2.6561
R3393 VGND.n1864 VGND.n191 2.6561
R3394 VGND.n190 VGND.n156 2.6561
R3395 VGND.n1876 VGND.n157 2.6561
R3396 VGND.n164 VGND.n163 2.6561
R3397 VGND.n1870 VGND.n1869 2.6561
R3398 VGND.n1208 VGND.n196 2.62971
R3399 VGND.n1087 VGND.n1072 2.62831
R3400 VGND.n998 VGND.n374 2.62326
R3401 VGND.n1858 VGND.n1857 2.61072
R3402 VGND.n1209 VGND.n1208 2.57121
R3403 VGND.n1969 VGND.n1968 2.5605
R3404 VGND.n42 VGND.n40 2.5605
R3405 VGND.n1963 VGND.n45 2.5605
R3406 VGND.n1962 VGND.n1960 2.5605
R3407 VGND.n1959 VGND.n46 2.5605
R3408 VGND.n1956 VGND.n1955 2.5605
R3409 VGND.n1951 VGND.n47 2.5605
R3410 VGND.n1950 VGND.n1947 2.5605
R3411 VGND.n1946 VGND.n1944 2.5605
R3412 VGND.n51 VGND.n30 2.5605
R3413 VGND.n1531 VGND.n1505 2.53355
R3414 VGND.n988 VGND.n382 2.52507
R3415 VGND.n54 VGND.n28 2.47966
R3416 VGND.n537 VGND.n324 2.4726
R3417 VGND.n753 VGND.n295 2.46298
R3418 VGND.n208 VGND.n203 2.46204
R3419 VGND.n1803 VGND.n197 2.46204
R3420 VGND.n1379 VGND.n39 2.45173
R3421 VGND.n813 VGND.n356 2.41639
R3422 VGND.n1443 VGND.n324 2.3078
R3423 VGND.n348 VGND.n347 2.29231
R3424 VGND.n1443 VGND.n1442 2.28033
R3425 VGND.n1857 VGND.n189 2.23121
R3426 VGND.n215 VGND.n213 2.163
R3427 VGND.n1794 VGND.n1792 2.163
R3428 VGND.n904 VGND.n903 2.14595
R3429 VGND.n1865 VGND.n1864 2.12498
R3430 VGND.n191 VGND.n190 2.12498
R3431 VGND.n163 VGND.n157 2.12498
R3432 VGND.n1870 VGND.n164 2.12498
R3433 VGND.n1502 VGND.n274 2.12311
R3434 VGND.n1625 VGND.n29 2.12311
R3435 VGND.n751 VGND.n292 2.1125
R3436 VGND.n1740 VGND.n1661 2.05178
R3437 VGND.n1869 VGND.n165 2.00854
R3438 VGND.n210 VGND.n209 1.96973
R3439 VGND.n209 VGND.n208 1.96973
R3440 VGND.n203 VGND.n197 1.96973
R3441 VGND.n1803 VGND.n1802 1.96973
R3442 VGND.n880 VGND.n516 1.951
R3443 VGND.n851 VGND.n775 1.951
R3444 VGND.n1471 VGND.n293 1.951
R3445 VGND.n1380 VGND.n38 1.951
R3446 VGND.n1233 VGND.n24 1.951
R3447 VGND.n1624 VGND.n21 1.951
R3448 VGND.n85 VGND.n25 1.951
R3449 VGND.n937 VGND.n936 1.951
R3450 VGND.n999 VGND.n372 1.951
R3451 VGND.n876 VGND.n514 1.89141
R3452 VGND.n847 VGND.n573 1.89141
R3453 VGND.n1802 VGND.n196 1.87127
R3454 VGND.n6 VGND.n5 1.8605
R3455 VGND.n1209 VGND.n1058 1.78975
R3456 VGND.n573 VGND.n569 1.74595
R3457 VGND.n514 VGND.n511 1.74595
R3458 VGND.n1983 VGND.n1982 1.67423
R3459 VGND.n910 VGND.n909 1.63037
R3460 VGND.n217 VGND.n216 1.55639
R3461 VGND.n4 VGND.n3 1.55639
R3462 VGND.n1877 VGND.n156 1.54075
R3463 VGND.n382 VGND.n380 1.46209
R3464 VGND.n1878 VGND.n1877 1.45707
R3465 VGND.n998 VGND.n373 1.4194
R3466 VGND.n810 VGND.n356 1.39918
R3467 VGND.n1796 VGND.n1795 1.32907
R3468 VGND.n1985 VGND.n1 1.32907
R3469 VGND.n1532 VGND.n268 1.32468
R3470 VGND.n1929 VGND.n55 1.3077
R3471 VGND.n913 VGND.n495 1.30296
R3472 VGND.n1210 VGND.n1209 1.25477
R3473 VGND VGND.n1989 1.24857
R3474 VGND.n1311 VGND.n1032 1.24081
R3475 VGND.n1314 VGND.n1030 1.24081
R3476 VGND.n1317 VGND.n1028 1.24081
R3477 VGND.n1320 VGND.n1026 1.24081
R3478 VGND.n1323 VGND.n1024 1.24081
R3479 VGND.n1332 VGND.n1331 1.24081
R3480 VGND.n1338 VGND.n1019 1.24081
R3481 VGND.n1337 VGND.n1014 1.24081
R3482 VGND.n9 VGND.n8 1.22044
R3483 VGND.n979 VGND.n978 1.21723
R3484 VGND.n975 VGND.n390 1.21723
R3485 VGND.n394 VGND.n391 1.21723
R3486 VGND.n969 VGND.n395 1.21723
R3487 VGND.n965 VGND.n964 1.21723
R3488 VGND.n438 VGND.n436 1.21723
R3489 VGND.n441 VGND.n421 1.21723
R3490 VGND.n447 VGND.n418 1.21723
R3491 VGND.n1309 VGND.n275 1.21689
R3492 VGND.n1385 VGND.n1384 1.20153
R3493 VGND.n596 VGND.n594 1.19453
R3494 VGND.n714 VGND.n713 1.19453
R3495 VGND.n629 VGND.n599 1.19453
R3496 VGND.n631 VGND.n626 1.19453
R3497 VGND.n637 VGND.n634 1.19453
R3498 VGND.n645 VGND.n642 1.19453
R3499 VGND.n647 VGND.n619 1.19453
R3500 VGND.n654 VGND.n651 1.19453
R3501 VGND.n1450 VGND.n322 1.19453
R3502 VGND.n1448 VGND.n310 1.19453
R3503 VGND.n1465 VGND.n311 1.19453
R3504 VGND.n1455 VGND.n313 1.19453
R3505 VGND.n1460 VGND.n1459 1.19453
R3506 VGND.n732 VGND.n725 1.19453
R3507 VGND.n737 VGND.n721 1.19453
R3508 VGND.n743 VGND.n742 1.19453
R3509 VGND.n1620 VGND.n1619 1.1912
R3510 VGND.n1616 VGND.n241 1.1912
R3511 VGND.n244 VGND.n242 1.1912
R3512 VGND.n1599 VGND.n1598 1.1912
R3513 VGND.n1520 VGND.n1519 1.1912
R3514 VGND.n1524 VGND.n1523 1.1912
R3515 VGND.n1537 VGND.n269 1.1912
R3516 VGND.n1091 VGND.n1072 1.18726
R3517 VGND.n1576 VGND.n235 1.163
R3518 VGND.n707 VGND.n295 1.15277
R3519 VGND.n904 VGND.n499 1.12777
R3520 VGND.n1896 VGND.n1895 1.11989
R3521 VGND.n1901 VGND.n82 1.11989
R3522 VGND.n1905 VGND.n78 1.11989
R3523 VGND.n1906 VGND.n77 1.11989
R3524 VGND.n1911 VGND.n73 1.11989
R3525 VGND.n72 VGND.n70 1.11989
R3526 VGND.n68 VGND.n62 1.11989
R3527 VGND.n1934 VGND.n63 1.11989
R3528 VGND.n1880 VGND.n1879 1.10777
R3529 VGND.n245 VGND.n155 1.09548
R3530 VGND.n911 VGND.n497 1.07944
R3531 VGND.n423 VGND 1.07122
R3532 VGND.n1311 VGND.n1309 1.04236
R3533 VGND.n1576 VGND.n237 1.04236
R3534 VGND.n150 VGND.n84 1.02255
R3535 VGND.n707 VGND.n594 1.00349
R3536 VGND.n727 VGND 1.00349
R3537 VGND.n1314 VGND.n1032 0.992748
R3538 VGND.n1317 VGND.n1030 0.992748
R3539 VGND.n1320 VGND.n1028 0.992748
R3540 VGND.n1323 VGND.n1026 0.992748
R3541 VGND.n1326 VGND.n1024 0.992748
R3542 VGND VGND.n1022 0.992748
R3543 VGND.n1332 VGND.n1022 0.992748
R3544 VGND.n1331 VGND.n1019 0.992748
R3545 VGND.n1338 VGND.n1337 0.992748
R3546 VGND.n1345 VGND.n1014 0.992748
R3547 VGND.n1619 VGND.n238 0.992748
R3548 VGND.n1616 VGND.n1615 0.992748
R3549 VGND.n1604 VGND.n244 0.992748
R3550 VGND.n1594 VGND.n249 0.992748
R3551 VGND.n1598 VGND.n250 0.992748
R3552 VGND.n1518 VGND.n1511 0.992748
R3553 VGND.n1520 VGND.n1508 0.992748
R3554 VGND.n1523 VGND.n1509 0.992748
R3555 VGND.n1537 VGND.n1536 0.992748
R3556 VGND.n1897 VGND.n1896 0.973884
R3557 VGND.n1901 VGND.n1900 0.973884
R3558 VGND.n1907 VGND.n1905 0.973884
R3559 VGND.n1910 VGND.n77 0.973884
R3560 VGND.n1916 VGND.n73 0.973884
R3561 VGND.n1920 VGND.n1919 0.973884
R3562 VGND.n70 VGND.n69 0.973884
R3563 VGND.n1935 VGND.n62 0.973884
R3564 VGND.n65 VGND.n63 0.973884
R3565 VGND.n714 VGND.n596 0.955724
R3566 VGND.n713 VGND.n599 0.955724
R3567 VGND.n631 VGND.n629 0.955724
R3568 VGND.n634 VGND.n626 0.955724
R3569 VGND.n639 VGND.n637 0.955724
R3570 VGND VGND.n622 0.955724
R3571 VGND.n642 VGND.n622 0.955724
R3572 VGND.n647 VGND.n645 0.955724
R3573 VGND.n651 VGND.n619 0.955724
R3574 VGND.n654 VGND.n653 0.955724
R3575 VGND.n1440 VGND.n1439 0.955724
R3576 VGND.n1345 VGND.n1344 0.943136
R3577 VGND.n1511 VGND 0.943136
R3578 VGND.n1658 VGND.n195 0.933163
R3579 VGND.n1781 VGND.n1780 0.931409
R3580 VGND.n1503 VGND.n273 0.9285
R3581 VGND.n1976 VGND.n1975 0.9285
R3582 VGND.n943 VGND.n386 0.925215
R3583 VGND.n419 VGND.n325 0.925215
R3584 VGND.n653 VGND.n357 0.907963
R3585 VGND.n1450 VGND.n1449 0.907963
R3586 VGND.n1466 VGND.n310 0.907963
R3587 VGND.n1455 VGND.n316 0.907963
R3588 VGND.n1459 VGND.n319 0.907963
R3589 VGND.n728 VGND.n727 0.907963
R3590 VGND.n732 VGND.n731 0.907963
R3591 VGND.n738 VGND.n737 0.907963
R3592 VGND.n742 VGND.n741 0.907963
R3593 VGND.n1385 VGND.n346 0.907963
R3594 VGND.n1344 VGND.n1006 0.893523
R3595 VGND.n270 VGND.n268 0.893523
R3596 VGND.n943 VGND.n942 0.876546
R3597 VGND.n978 VGND.n387 0.876546
R3598 VGND.n975 VGND.n974 0.876546
R3599 VGND.n970 VGND.n394 0.876546
R3600 VGND.n399 VGND.n395 0.876546
R3601 VGND.n964 VGND.n400 0.876546
R3602 VGND.n428 VGND.n423 0.876546
R3603 VGND.n438 VGND.n437 0.876546
R3604 VGND.n442 VGND.n441 0.876546
R3605 VGND.n447 VGND.n446 0.876546
R3606 VGND.n1442 VGND.n325 0.876546
R3607 VGND.n151 VGND.n150 0.876546
R3608 VGND.n1920 VGND 0.876546
R3609 VGND.n1005 VGND.n357 0.860201
R3610 VGND.n1441 VGND.n1440 0.860201
R3611 VGND.n1888 VGND.n1887 0.844053
R3612 VGND.n941 VGND.n486 0.834494
R3613 VGND.n1930 VGND.n1929 0.827876
R3614 VGND.n1374 VGND.n350 0.804872
R3615 VGND.n1079 VGND.n1078 0.804872
R3616 VGND.n1364 VGND.n1363 0.763414
R3617 VGND.n1779 VGND.n1662 0.729404
R3618 VGND.n4 VGND 0.72153
R3619 VGND.n1790 VGND.n1789 0.715885
R3620 VGND.n497 VGND.n311 0.693037
R3621 VGND.n1184 VGND.n1183 0.689009
R3622 VGND.n1791 VGND 0.629641
R3623 VGND.n1603 VGND.n245 0.620655
R3624 VGND.n1780 VGND.n219 0.60792
R3625 VGND.n1061 VGND.n1058 0.605553
R3626 VGND VGND.n1790 0.6005
R3627 VGND.n1877 VGND.n1876 0.584732
R3628 VGND.n1594 VGND.n245 0.571043
R3629 VGND.n217 VGND 0.567
R3630 VGND.n910 VGND.n382 0.517167
R3631 VGND.n1988 VGND 0.502941
R3632 VGND.n210 VGND.n165 0.492808
R3633 VGND.n994 VGND.n373 0.487697
R3634 VGND.n912 VGND.n911 0.434711
R3635 VGND.n1878 VGND.n155 0.418921
R3636 VGND.n1742 VGND.n1741 0.399116
R3637 VGND.n912 VGND.n155 0.382079
R3638 VGND.n1101 VGND.n1100 0.381957
R3639 VGND.n866 VGND 0.364136
R3640 VGND.n837 VGND 0.364136
R3641 VGND.n895 VGND 0.364136
R3642 VGND.n1378 VGND.n329 0.357582
R3643 VGND.n1780 VGND.n1779 0.320776
R3644 VGND.n1969 VGND.n39 0.3205
R3645 VGND.n1968 VGND.n40 0.3205
R3646 VGND.n45 VGND.n42 0.3205
R3647 VGND.n1963 VGND.n1962 0.3205
R3648 VGND.n1960 VGND.n1959 0.3205
R3649 VGND.n1956 VGND.n46 0.3205
R3650 VGND.n1955 VGND.n47 0.3205
R3651 VGND.n1951 VGND.n1950 0.3205
R3652 VGND.n1947 VGND.n1946 0.3205
R3653 VGND.n1944 VGND.n51 0.3205
R3654 VGND.n1975 VGND.n30 0.3205
R3655 VGND.n314 VGND.n11 0.313491
R3656 VGND.n1795 VGND.n1794 0.301705
R3657 VGND.n909 VGND.n2 0.283833
R3658 VGND.n1379 VGND.n1378 0.275178
R3659 VGND.n1184 VGND.n1058 0.271731
R3660 VGND.n1326 VGND 0.248562
R3661 VGND VGND.n1510 0.248562
R3662 VGND.n1879 VGND.n1878 0.245237
R3663 VGND.n1915 VGND 0.243846
R3664 VGND.n639 VGND 0.239306
R3665 VGND.n913 VGND.n912 0.233
R3666 VGND.n497 VGND.n496 0.215425
R3667 VGND.n1791 VGND.n215 0.199295
R3668 VGND VGND.n726 0.191545
R3669 VGND.n218 VGND 0.186214
R3670 VGND.n1741 VGND.n1662 0.16616
R3671 VGND.n1183 VGND.n1101 0.156979
R3672 VGND VGND.n422 0.146508
R3673 VGND.n1442 VGND.n1441 0.137839
R3674 VGND.n911 VGND.n910 0.129447
R3675 VGND.n1987 VGND.n1 0.118242
R3676 VGND.n55 VGND.n54 0.108289
R3677 VGND.n1977 VGND.n28 0.108289
R3678 VGND.n979 VGND.n386 0.0978384
R3679 VGND.n390 VGND.n387 0.0978384
R3680 VGND.n974 VGND.n391 0.0978384
R3681 VGND.n970 VGND.n969 0.0978384
R3682 VGND.n965 VGND.n399 0.0978384
R3683 VGND.n422 VGND.n400 0.0978384
R3684 VGND.n436 VGND.n428 0.0978384
R3685 VGND.n437 VGND.n421 0.0978384
R3686 VGND.n442 VGND.n418 0.0978384
R3687 VGND.n446 VGND.n419 0.0978384
R3688 VGND.n1895 VGND.n84 0.0978384
R3689 VGND.n1897 VGND.n82 0.0978384
R3690 VGND.n1900 VGND.n78 0.0978384
R3691 VGND.n1907 VGND.n1906 0.0978384
R3692 VGND.n1911 VGND.n1910 0.0978384
R3693 VGND.n1916 VGND.n1915 0.0978384
R3694 VGND.n1919 VGND.n72 0.0978384
R3695 VGND.n69 VGND.n68 0.0978384
R3696 VGND.n1935 VGND.n1934 0.0978384
R3697 VGND.n1930 VGND.n65 0.0978384
R3698 VGND VGND.n1 0.0952581
R3699 VGND.n5 VGND 0.0814352
R3700 VGND.n1976 VGND.n29 0.0813421
R3701 VGND.n906 VGND.n2 0.0786513
R3702 VGND.n1795 VGND.n1791 0.0727892
R3703 VGND.n1532 VGND.n1531 0.0543947
R3704 VGND.n1505 VGND.n1504 0.0543947
R3705 VGND.n1607 VGND.n1606 0.0543947
R3706 VGND.n1608 VGND.n235 0.0543947
R3707 VGND.n218 VGND.n217 0.054
R3708 VGND.n218 VGND 0.0525
R3709 VGND.n1620 VGND.n237 0.0501124
R3710 VGND.n241 VGND.n238 0.0501124
R3711 VGND.n1615 VGND.n242 0.0501124
R3712 VGND.n1604 VGND.n1603 0.0501124
R3713 VGND.n1599 VGND.n249 0.0501124
R3714 VGND.n1510 VGND.n250 0.0501124
R3715 VGND.n1519 VGND.n1518 0.0501124
R3716 VGND.n1524 VGND.n1508 0.0501124
R3717 VGND.n1509 VGND.n269 0.0501124
R3718 VGND.n1536 VGND.n270 0.0501124
R3719 VGND.n1384 VGND.n347 0.0492619
R3720 VGND.n750 VGND.n348 0.0492619
R3721 VGND.n1439 VGND.n322 0.0482612
R3722 VGND.n1449 VGND.n1448 0.0482612
R3723 VGND.n1466 VGND.n1465 0.0482612
R3724 VGND.n496 VGND.n313 0.0482612
R3725 VGND.n1460 VGND.n316 0.0482612
R3726 VGND.n726 VGND.n319 0.0482612
R3727 VGND.n728 VGND.n725 0.0482612
R3728 VGND.n731 VGND.n721 0.0482612
R3729 VGND.n743 VGND.n738 0.0482612
R3730 VGND.n741 VGND.n346 0.0482612
R3731 VGND.n1989 VGND.n2 0.03175
R3732 VGND.n1503 VGND.n1502 0.0274474
R3733 VGND.n752 VGND.n751 0.024881
R3734 VGND.n5 VGND.n4 0.0144388
R3735 VGND.n1989 VGND.n1988 0.00908779
R3736 VGND.n1794 VGND 0.00803012
C0 MSU2.S M1.G0 0.30204f
C1 Q1.Emitter RPTAT_lay_0.B 1.72159f
C2 VDPWR M1.G0 30.9183f
C3 MSU2.S M1.S1 0.14076f
C4 MSU1.S M1.S1 0.28305f
C5 M1.S1 VDPWR 2.50673f
C6 ua[0] VDPWR 2.55818f
C7 M1.S1 M1.G0 9.11225f
C8 RCTAT_lay_0.A RCTAT_lay_0.sky130_fd_pr__res_xhigh_po_0p35_7LQ4N7_4.R1 0.11208f
C9 RCTAT_lay_0.sky130_fd_pr__res_xhigh_po_0p35_7LQ4N7_3.R2 RCTAT_lay_0.sky130_fd_pr__res_xhigh_po_0p35_7LQ4N7_1.R2 0.26025f
C10 ua[0] M1.G0 4.35098f
C11 ua[0] RL_lay_0.R3.R1 0.39297f
C12 RCTAT_lay_0.A M1.G0 2.23607f
C13 RCTAT_lay_0.sky130_fd_pr__res_xhigh_po_0p35_7LQ4N7_2.R1 RCTAT_lay_0.sky130_fd_pr__res_xhigh_po_0p35_7LQ4N7_4.R1 0.26035f
C14 RCTAT_lay_0.A M1.S1 4.21255f
C15 RL_lay_0.R4.R2 RL_lay_0.sky130_fd_pr__res_xhigh_po_0p35_RTNBCE_0.R2 0.26016f
C16 RCTAT_lay_0.sky130_fd_pr__res_xhigh_po_0p35_7LQ4N7_5.R2 RCTAT_lay_0.sky130_fd_pr__res_xhigh_po_0p35_7LQ4N7_3.R2 0.26016f
C17 M1.S1 Q1.Emitter 5.38192f
C18 M1.S1 RPTAT_lay_0.B 0.20207f
C19 RCTAT_lay_0.sky130_fd_pr__res_xhigh_po_0p35_7LQ4N7_2.R1 RCTAT_lay_0.A 0.41492f
C20 RCTAT_lay_0.A Q1.Emitter 0.36175f
C21 RCTAT_lay_0.A RPTAT_lay_0.B 0.83121f
C22 MSU1.S MSU2.S 0.44158f
C23 MSU2.S VDPWR 1.33148f
C24 MSU1.S VDPWR 0.84548f
C25 ua[0] VGND 2.96105f
C26 VDPWR VGND 61.29891f
C27 RCTAT_lay_0.sky130_fd_pr__res_xhigh_po_0p35_7LQ4N7_5.R2 VGND 0.78807f
C28 RCTAT_lay_0.sky130_fd_pr__res_xhigh_po_0p35_7LQ4N7_4.R1 VGND 0.76531f
C29 RCTAT_lay_0.sky130_fd_pr__res_xhigh_po_0p35_7LQ4N7_3.R2 VGND 0.51652f
C30 RCTAT_lay_0.sky130_fd_pr__res_xhigh_po_0p35_7LQ4N7_2.R1 VGND 0.50879f
C31 RCTAT_lay_0.sky130_fd_pr__res_xhigh_po_0p35_7LQ4N7_1.R2 VGND 0.77626f
C32 RL_lay_0.R4.R2 VGND 0.72086f
C33 RL_lay_0.R3.R1 VGND 0.70607f
C34 RL_lay_0.sky130_fd_pr__res_xhigh_po_0p35_RTNBCE_0.R2 VGND 0.70975f
C35 RPTAT_lay_0.B VGND 15.2039f
C36 MSU2.S VGND 0.49583f
C37 MSU1.S VGND 0.37859f
C38 RCTAT_lay_0.A VGND 9.42809f
C39 Q1.Emitter VGND 5.43069f
C40 M1.S1 VGND 17.262f
C41 M1.G0 VGND 4.05359f
C42 VDPWR.n99 VGND 0.17826f
C43 VDPWR.n100 VGND 0.5828f
C44 VDPWR.n101 VGND 0.44668f
C45 VDPWR.n102 VGND 0.38237f
C46 VDPWR.n103 VGND 0.27232f
C47 VDPWR.n104 VGND 0.33587f
C48 VDPWR.n105 VGND 3.54397f
C49 VDPWR.n106 VGND 0.62085f
C50 VDPWR.n107 VGND 0.97143f
C51 VDPWR.t37 VGND 0.29907f
C52 VDPWR.t36 VGND 0.30235f
C53 VDPWR.t34 VGND 1.19278f
C54 VDPWR.t32 VGND 1.03415f
C55 VDPWR.n108 VGND 0.68672f
C56 VDPWR.t30 VGND 0.56543f
C57 VDPWR.t28 VGND 0.55495f
C58 VDPWR.n109 VGND 0.53075f
C59 VDPWR.t26 VGND 1.0373f
C60 VDPWR.t24 VGND 1.29665f
C61 VDPWR.t22 VGND 1.12114f
C62 VDPWR.t20 VGND 0.97786f
C63 VDPWR.t18 VGND 0.73191f
C64 VDPWR.t0 VGND 1.22604f
C65 VDPWR.t2 VGND 0.97786f
C66 VDPWR.t4 VGND 0.97786f
C67 VDPWR.t6 VGND 0.97786f
C68 VDPWR.t8 VGND 0.97786f
C69 VDPWR.t10 VGND 1.17254f
C70 VDPWR.t12 VGND 1.17254f
C71 VDPWR.t14 VGND 0.97786f
C72 VDPWR.t16 VGND 0.73488f
C73 VDPWR.n110 VGND 0.48893f
C74 VDPWR.n111 VGND 0.76807f
C75 VDPWR.n112 VGND 4.16501f
C76 VDPWR.n113 VGND 0.10755f
C77 VDPWR.n114 VGND 0.3375f
C78 VDPWR.n115 VGND 0.38001f
C79 VDPWR.n116 VGND 0.27395f
C80 VDPWR.n117 VGND 0.44668f
C81 VDPWR.n118 VGND 0.83703f
C82 ua[0].n7 VGND 0.12168f
C83 ua[0].n10 VGND 0.16932f
C84 ua[0].n11 VGND 0.17555f
C85 ua[0].n12 VGND 0.26713f
C86 ua[0].n13 VGND 0.12811f
C87 ua[0].n17 VGND 0.38805f
C88 ua[0].n27 VGND 0.12744f
C89 ua[0].n32 VGND 0.38138f
C90 ua[0].n33 VGND 0.51364f
C91 ua[0].n34 VGND 0.3734f
C92 ua[0].n46 VGND 0.14124f
C93 ua[0].n51 VGND 0.12728f
C94 ua[0].n53 VGND 0.12029f
C95 ua[0].n54 VGND 0.22095f
C96 ua[0].n55 VGND 1.13973f
C97 ua[0].n56 VGND 0.1898f
C98 ua[0].n57 VGND 0.23514f
.ends
