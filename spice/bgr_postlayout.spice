* NGSPICE file created from bgr_core.ext - technology: sky130A

.subckt bgr_core VDPWR VGND ua[0] ui_in[0]
X0 VDPWR.t11 M1.G0 M1.S1 VDPWR.t10 sky130_fd_pr__pfet_01v8_lvt ad=1.45 pd=10.58 as=0.725 ps=5.29 w=5 l=3
X1 M1.G0 M1.S1 RCTAT_lay_0.A VGND.t7 sky130_fd_pr__nfet_01v8_lvt ad=0.725 pd=5.29 as=0.725 ps=5.29 w=5 l=3
X2 M1.G0 ui_in[0].t2 VDPWR.t44 VDPWR.t43 sky130_fd_pr__pfet_01v8 ad=0.348 pd=2.98 as=0.348 ps=2.98 w=1.2 l=1
X3 RCTAT_lay_0.A RCTAT_lay_0.sky130_fd_pr__res_xhigh_po_0p35_7LQ4N7_1.R2 VGND.t13 sky130_fd_pr__res_xhigh_po_0p35 l=4.08
X4 M1.S1 M1.G0 VDPWR.t5 VDPWR.t4 sky130_fd_pr__pfet_01v8_lvt ad=0.725 pd=5.29 as=0.725 ps=5.29 w=5 l=3
X5 VGND.t31 VGND.t33 RPTAT_lay_0.B sky130_fd_pr__pnp_05v5_W3p40L3p40
**devattr s=462400,2720 d=48028815,56131
X6 M1.S1 M1.G0 VDPWR.t1 VDPWR.t0 sky130_fd_pr__pfet_01v8_lvt ad=0.725 pd=5.29 as=1.45 ps=10.58 w=5 l=3
X7 M1.G0 M1.S1 RCTAT_lay_0.A VGND.t7 sky130_fd_pr__nfet_01v8_lvt ad=0.725 pd=5.29 as=0.725 ps=5.29 w=5 l=3
X8 inv_0.Y ui_in[0].t4 VDPWR.t40 VDPWR.t39 sky130_fd_pr__pfet_01v8 ad=0.58 pd=4.58 as=0.58 ps=4.58 w=2 l=0.5
X9 ua[0].t6 RL_lay_0.sky130_fd_pr__res_xhigh_po_0p35_RTNBCE_0.R2 VGND.t21 sky130_fd_pr__res_xhigh_po_0p35 l=4.18
X10 RL_lay_0.R3.R1 RL_lay_0.sky130_fd_pr__res_xhigh_po_0p35_RTNBCE_0.R2 VGND.t17 sky130_fd_pr__res_xhigh_po_0p35 l=4.18
X11 VDPWR.t15 M1.G0 M1.G0 VDPWR.t14 sky130_fd_pr__pfet_01v8_lvt ad=0.725 pd=5.29 as=0.725 ps=5.29 w=5 l=3
X12 VGND.t29 VGND.t28 Q1.Emitter sky130_fd_pr__pnp_05v5_W3p40L3p40
**devattr s=462400,2720 d=48028815,56131
X13 ME2.S ui_in[0].t0 M1.S1 VGND.t24 sky130_fd_pr__nfet_01v8 ad=0.29 pd=2.58 as=0.29 ps=2.58 w=1 l=0.3
X14 RCTAT_lay_0.sky130_fd_pr__res_xhigh_po_0p35_7LQ4N7_2.R1 RCTAT_lay_0.sky130_fd_pr__res_xhigh_po_0p35_7LQ4N7_1.R2 VGND.t27 sky130_fd_pr__res_xhigh_po_0p35 l=4.08
X15 VGND.t36 VGND.t35 RPTAT_lay_0.B sky130_fd_pr__pnp_05v5_W3p40L3p40
**devattr s=462400,2720 d=48028815,56131
X16 VGND.t29 VGND.t37 RPTAT_lay_0.B sky130_fd_pr__pnp_05v5_W3p40L3p40
**devattr s=462400,2720 d=48028815,56131
X17 VGND.t26 RCTAT_lay_0.sky130_fd_pr__res_xhigh_po_0p35_7LQ4N7_5.R2 VGND.t25 sky130_fd_pr__res_xhigh_po_0p35 l=4.08
X18 VDPWR.t19 M1.G0 M1.G0 VDPWR.t18 sky130_fd_pr__pfet_01v8_lvt ad=0.725 pd=5.29 as=0.725 ps=5.29 w=5 l=3
X19 Q1.Emitter M1.S1 M1.S1 VGND.t6 sky130_fd_pr__nfet_01v8_lvt ad=1.45 pd=10.58 as=0.725 ps=5.29 w=5 l=3
X20 RCTAT_lay_0.A M1.S1 M1.G0 VGND.t7 sky130_fd_pr__nfet_01v8_lvt ad=1.45 pd=10.58 as=0.725 ps=5.29 w=5 l=3
X21 ME1.S ui_in[0].t3 VDPWR.t42 VDPWR.t41 sky130_fd_pr__pfet_01v8 ad=0.348 pd=2.98 as=0.348 ps=2.98 w=1.2 l=1
X22 RL_lay_0.R3.R1 RL_lay_0.R4.R2 VGND.t16 sky130_fd_pr__res_xhigh_po_0p35 l=4.18
X23 VDPWR.t3 M1.G0 M1.S1 VDPWR.t2 sky130_fd_pr__pfet_01v8_lvt ad=0.725 pd=5.29 as=0.725 ps=5.29 w=5 l=3
X24 M1.S1 M1.S1 Q1.Emitter VGND.t3 sky130_fd_pr__nfet_01v8_lvt ad=0.725 pd=5.29 as=0.725 ps=5.29 w=5 l=3
X25 RCTAT_lay_0.A M1.S1 M1.G0 VGND.t7 sky130_fd_pr__nfet_01v8_lvt ad=0.725 pd=5.29 as=0.725 ps=5.29 w=5 l=3
X26 VGND.t31 VGND.t30 RPTAT_lay_0.B sky130_fd_pr__pnp_05v5_W3p40L3p40
**devattr s=462400,2720 d=48028815,56131
X27 M1.S1 M1.S1 Q1.Emitter VGND.t1 sky130_fd_pr__nfet_01v8_lvt ad=0.725 pd=5.29 as=1.45 ps=10.58 w=5 l=3
X28 inv_0.Y ui_in[0].t1 VGND.t23 VGND.t22 sky130_fd_pr__nfet_01v8 ad=0.145 pd=1.58 as=0.145 ps=1.58 w=0.5 l=0.5
X29 VGND.t29 VGND.t38 RPTAT_lay_0.B sky130_fd_pr__pnp_05v5_W3p40L3p40
**devattr s=462400,2720 d=48028815,56131
X30 RCTAT_lay_0.A RPTAT_lay_0.B VGND.t0 sky130_fd_pr__res_xhigh_po_0p35 l=3.2
X31 RCTAT_lay_0.sky130_fd_pr__res_xhigh_po_0p35_7LQ4N7_2.R1 RCTAT_lay_0.sky130_fd_pr__res_xhigh_po_0p35_7LQ4N7_3.R2 VGND.t20 sky130_fd_pr__res_xhigh_po_0p35 l=4.08
X32 ua[0].t1 M1.G0 VDPWR.t25 VDPWR.t24 sky130_fd_pr__pfet_01v8_lvt ad=0.725 pd=5.29 as=1.45 ps=10.58 w=5 l=3
X33 VGND.t15 RL_lay_0.R4.R2 VGND.t14 sky130_fd_pr__res_xhigh_po_0p35 l=4.18
X34 MSU1.S M1.S1 VGND.t9 VGND.t8 sky130_fd_pr__nfet_01v8 ad=0.29 pd=2.58 as=0.29 ps=2.58 w=1 l=2
X35 M1.G0 ME1.S ME2.S VGND.t10 sky130_fd_pr__nfet_01v8 ad=0.145 pd=1.58 as=0.145 ps=1.58 w=0.5 l=0.15
X36 VGND.t31 VGND.t32 RPTAT_lay_0.B sky130_fd_pr__pnp_05v5_W3p40L3p40
**devattr s=462400,2720 d=48028815,56131
X37 ME1.S ME1.S VDPWR.t38 VDPWR.t37 sky130_fd_pr__pfet_01v8 ad=0.29 pd=2.58 as=0.29 ps=2.58 w=1 l=2
X38 ua[0].t5 M1.G0 VDPWR.t33 VDPWR.t32 sky130_fd_pr__pfet_01v8_lvt ad=0.725 pd=5.29 as=0.725 ps=5.29 w=5 l=3
X39 VDPWR.t35 M1.G0 ua[0].t0 VDPWR.t34 sky130_fd_pr__pfet_01v8_lvt ad=1.45 pd=10.58 as=0.725 ps=5.29 w=5 l=3
X40 M1.G0 M1.G0 VDPWR.t13 VDPWR.t12 sky130_fd_pr__pfet_01v8_lvt ad=0.725 pd=5.29 as=1.45 ps=10.58 w=5 l=3
X41 VGND.t29 VGND.t34 RPTAT_lay_0.B sky130_fd_pr__pnp_05v5_W3p40L3p40
**devattr s=462400,2720 d=48028815,56131
X42 RCTAT_lay_0.sky130_fd_pr__res_xhigh_po_0p35_7LQ4N7_4.R1 RCTAT_lay_0.sky130_fd_pr__res_xhigh_po_0p35_7LQ4N7_3.R2 VGND.t19 sky130_fd_pr__res_xhigh_po_0p35 l=4.08
X43 Q1.Emitter M1.S1 M1.S1 VGND.t2 sky130_fd_pr__nfet_01v8_lvt ad=0.725 pd=5.29 as=0.725 ps=5.29 w=5 l=3
X44 VDPWR.t7 M1.G0 M1.S1 VDPWR.t6 sky130_fd_pr__pfet_01v8_lvt ad=0.725 pd=5.29 as=0.725 ps=5.29 w=5 l=3
X45 M1.S1 M1.G0 VDPWR.t9 VDPWR.t8 sky130_fd_pr__pfet_01v8_lvt ad=0.725 pd=5.29 as=0.725 ps=5.29 w=5 l=3
X46 RCTAT_lay_0.A M1.S1 M1.G0 VGND.t7 sky130_fd_pr__nfet_01v8_lvt ad=0.725 pd=5.29 as=0.725 ps=5.29 w=5 l=3
X47 M1.G0 M1.S1 RCTAT_lay_0.A VGND.t7 sky130_fd_pr__nfet_01v8_lvt ad=0.725 pd=5.29 as=1.45 ps=10.58 w=5 l=3
X48 VDPWR.t27 M1.G0 ua[0].t3 VDPWR.t26 sky130_fd_pr__pfet_01v8_lvt ad=0.725 pd=5.29 as=0.725 ps=5.29 w=5 l=3
X49 ua[0].t4 M1.G0 VDPWR.t29 VDPWR.t28 sky130_fd_pr__pfet_01v8_lvt ad=0.725 pd=5.29 as=0.725 ps=5.29 w=5 l=3
X50 RCTAT_lay_0.sky130_fd_pr__res_xhigh_po_0p35_7LQ4N7_4.R1 RCTAT_lay_0.sky130_fd_pr__res_xhigh_po_0p35_7LQ4N7_5.R2 VGND.t18 sky130_fd_pr__res_xhigh_po_0p35 l=4.08
X51 MSU1.S MSU1.S ME1.S VDPWR.t36 sky130_fd_pr__pfet_01v8 ad=0.29 pd=2.58 as=0.29 ps=2.58 w=1 l=2
X52 M1.G0 M1.G0 VDPWR.t21 VDPWR.t20 sky130_fd_pr__pfet_01v8_lvt ad=0.725 pd=5.29 as=0.725 ps=5.29 w=5 l=3
X53 VDPWR.t23 M1.G0 M1.G0 VDPWR.t22 sky130_fd_pr__pfet_01v8_lvt ad=1.45 pd=10.58 as=0.725 ps=5.29 w=5 l=3
X54 M1.S1 inv_0.Y VGND.t12 VGND.t11 sky130_fd_pr__nfet_01v8 ad=0.145 pd=1.58 as=0.145 ps=1.58 w=0.5 l=0.5
X55 M1.G0 M1.G0 VDPWR.t17 VDPWR.t16 sky130_fd_pr__pfet_01v8_lvt ad=0.725 pd=5.29 as=0.725 ps=5.29 w=5 l=3
X56 VDPWR.t31 M1.G0 ua[0].t2 VDPWR.t30 sky130_fd_pr__pfet_01v8_lvt ad=0.725 pd=5.29 as=0.725 ps=5.29 w=5 l=3
X57 Q1.Emitter M1.S1 M1.S1 VGND.t4 sky130_fd_pr__nfet_01v8_lvt ad=0.725 pd=5.29 as=0.725 ps=5.29 w=5 l=3
X58 M1.S1 M1.S1 Q1.Emitter VGND.t5 sky130_fd_pr__nfet_01v8_lvt ad=0.725 pd=5.29 as=0.725 ps=5.29 w=5 l=3
X59 VGND.t36 VGND.t39 RPTAT_lay_0.B sky130_fd_pr__pnp_05v5_W3p40L3p40
**devattr s=462400,2720 d=48028815,56131
R0 ui_in[0] ui_in[0].t0 274.108
R1 ui_in[0] ui_in[0].t4 248.4
R2 ui_in[0] ui_in[0].t3 180.921
R3 ui_in[0] ui_in[0].t2 180.921
R4 ui_in[0] ui_in[0].t1 176.101
R5 ui_in[0].n7 ui_in[0] 22.8534
R6 ui_in[0] ui_in[0].n6 22.8534
R7 ui_in[0] ui_in[0].n8 14.8416
R8 ui_in[0].n2 ui_in[0] 12.7032
R9 ui_in[0].n3 ui_in[0] 9.5505
R10 ui_in[0].n3 ui_in[0] 9.47907
R11 ui_in[0].n4 ui_in[0] 8.72531
R12 ui_in[0].n6 ui_in[0].n5 4.55586
R13 ui_in[0].n4 ui_in[0] 4.55362
R14 ui_in[0].n8 ui_in[0].n7 4.54514
R15 ui_in[0].n1 ui_in[0].n0 4.5005
R16 ui_in[0].n5 ui_in[0].n4 2.5572
R17 ui_in[0] ui_in[0].n3 0.383312
R18 ui_in[0].n8 ui_in[0].n0 0.0893889
R19 ui_in[0].n5 ui_in[0].n0 0.0893889
R20 ui_in[0].n7 ui_in[0].n1 0.0701429
R21 ui_in[0].n6 ui_in[0].n2 0.0505
R22 ui_in[0].n2 ui_in[0].n1 0.00942857
R23 ua[0].n38 ua[0].n37 585
R24 ua[0].n38 ua[0].n28 585
R25 ua[0].n38 ua[0].n27 585
R26 ua[0].n38 ua[0] 585
R27 ua[0].n39 ua[0].n38 585
R28 ua[0].n38 ua[0].n25 585
R29 ua[0].n38 ua[0].n13 585
R30 ua[0].n60 ua[0].n4 585
R31 ua[0] ua[0].n60 585
R32 ua[0].n60 ua[0].n3 585
R33 ua[0].n60 ua[0].n59 289.262
R34 ua[0].n60 ua[0].n2 289.26
R35 ua[0].n49 ua[0].n46 192.279
R36 ua[0].n47 ua[0].n46 144.278
R37 ua[0].n16 ua[0].t6 40.8142
R38 ua[0].n16 ua[0] 33.275
R39 ua[0].n22 ua[0].n13 25.4862
R40 ua[0].n37 ua[0].n29 25.4709
R41 ua[0].n49 ua[0].n48 24.5584
R42 ua[0].n52 ua[0].n2 19.6002
R43 ua[0].n59 ua[0].n5 19.5986
R44 ua[0].n36 ua[0].n28 16.5652
R45 ua[0].n25 ua[0].n24 16.5652
R46 ua[0].n31 ua[0].n27 15.0593
R47 ua[0].n39 ua[0].n12 15.0593
R48 ua[0].n5 ua[0].n4 15.0593
R49 ua[0].n52 ua[0].n3 15.0593
R50 ua[0].n59 ua[0].n58 14.6037
R51 ua[0].n7 ua[0].n2 14.5505
R52 ua[0] ua[0].n47 13.7368
R53 ua[0].n26 ua[0] 13.5534
R54 ua[0].n40 ua[0] 13.5534
R55 ua[0].n48 ua[0] 13.5534
R56 ua[0] ua[0].n0 13.5534
R57 ua[0] ua[0].n1 13.5534
R58 ua[0].n27 ua[0].n26 12.0476
R59 ua[0].n40 ua[0].n39 12.0476
R60 ua[0].n4 ua[0].n0 12.0476
R61 ua[0].n3 ua[0].n1 12.0476
R62 ua[0].n31 ua[0].n28 10.5417
R63 ua[0].n25 ua[0].n12 10.5417
R64 ua[0].n50 ua[0].n49 9.51453
R65 ua[0].n24 ua[0].n23 9.3005
R66 ua[0].n12 ua[0].n11 9.3005
R67 ua[0].n41 ua[0].n40 9.3005
R68 ua[0].n36 ua[0].n35 9.3005
R69 ua[0].n32 ua[0].n31 9.3005
R70 ua[0].n26 ua[0].n10 9.3005
R71 ua[0].n48 ua[0].n45 9.3005
R72 ua[0].n53 ua[0].n52 9.3005
R73 ua[0].n54 ua[0].n1 9.3005
R74 ua[0].n6 ua[0].n5 9.3005
R75 ua[0].n51 ua[0].n0 9.3005
R76 ua[0].n37 ua[0].n36 9.03579
R77 ua[0].n24 ua[0].n13 9.03579
R78 ua[0].n47 ua[0].n45 6.74741
R79 ua[0].n38 ua[0].t0 5.7135
R80 ua[0].n38 ua[0].t5 5.7135
R81 ua[0].n46 ua[0].t3 5.7135
R82 ua[0].n46 ua[0].t1 5.7135
R83 ua[0].n60 ua[0].t2 5.7135
R84 ua[0].n60 ua[0].t4 5.7135
R85 ua[0].n33 ua[0].n29 4.53859
R86 ua[0].n56 ua[0].n55 4.5005
R87 ua[0].n34 ua[0].n33 4.5005
R88 ua[0].n30 ua[0].n8 4.5005
R89 ua[0].n14 ua[0].n9 4.5005
R90 ua[0].n22 ua[0].n21 4.5005
R91 ua[0].n56 ua[0].n50 1.69172
R92 ua[0].n17 ua[0].n16 1.55639
R93 ua[0].n57 ua[0].n44 1.30258
R94 ua[0].n43 ua[0].n42 1.1255
R95 ua[0].n20 ua[0] 1.0131
R96 ua[0].n20 ua[0].n19 0.870692
R97 ua[0].n58 ua[0].n57 0.84425
R98 ua[0].n57 ua[0].n7 0.84425
R99 ua[0].n15 ua[0] 0.764639
R100 ua[0].n21 ua[0].n20 0.477331
R101 ua[0].n15 ua[0] 0.361801
R102 ua[0].n18 ua[0] 0.193833
R103 ua[0].n17 ua[0] 0.181151
R104 ua[0].n19 ua[0].n15 0.0796667
R105 ua[0].n19 ua[0].n18 0.0796667
R106 ua[0].n41 ua[0].n11 0.0647857
R107 ua[0].n51 ua[0].n6 0.0647857
R108 ua[0].n54 ua[0].n53 0.0647857
R109 ua[0].n53 ua[0].n7 0.0621071
R110 ua[0].n42 ua[0].n10 0.0585357
R111 ua[0].n43 ua[0].n9 0.0576429
R112 ua[0].n55 ua[0].n51 0.05675
R113 ua[0].n44 ua[0].n8 0.0564524
R114 ua[0].n23 ua[0].n14 0.0496071
R115 ua[0].n35 ua[0].n34 0.04425
R116 ua[0].n33 ua[0].n8 0.0385952
R117 ua[0].n21 ua[0].n9 0.0385952
R118 ua[0].n32 ua[0].n30 0.0371071
R119 ua[0].n30 ua[0].n10 0.0281786
R120 ua[0].n34 ua[0].n32 0.0210357
R121 ua[0].n18 ua[0].n17 0.0184795
R122 ua[0].n14 ua[0].n11 0.0156786
R123 ua[0].n35 ua[0].n29 0.0138929
R124 ua[0].n58 ua[0].n6 0.0138929
R125 ua[0].n23 ua[0].n22 0.00853571
R126 ua[0].n55 ua[0].n54 0.00853571
R127 ua[0].n42 ua[0].n41 0.00675
R128 ua[0].n57 ua[0].n56 0.00570833
R129 ua[0].n44 ua[0].n43 0.00169048
R130 ua[0].n50 ua[0].n45 0.00139286
R131 VDPWR.n148 VDPWR.n107 9051.59
R132 VDPWR.n130 VDPWR.n127 3068.63
R133 VDPWR.n129 VDPWR.n106 1031.56
R134 VDPWR.t12 VDPWR.t10 638.889
R135 VDPWR VDPWR.t38 613.566
R136 VDPWR VDPWR.t44 608.804
R137 VDPWR VDPWR.t42 608.804
R138 VDPWR.n117 VDPWR.n116 585
R139 VDPWR.n98 VDPWR.n97 585
R140 VDPWR.n97 VDPWR.n90 585
R141 VDPWR.n97 VDPWR.n96 585
R142 VDPWR.n97 VDPWR 585
R143 VDPWR.n86 VDPWR.n85 585
R144 VDPWR.n85 VDPWR.n84 585
R145 VDPWR.n85 VDPWR.n79 585
R146 VDPWR.n85 VDPWR 585
R147 VDPWR.n74 VDPWR.n73 585
R148 VDPWR.n73 VDPWR.n72 585
R149 VDPWR.n73 VDPWR.n67 585
R150 VDPWR.n73 VDPWR 585
R151 VDPWR.n62 VDPWR.n61 585
R152 VDPWR.n61 VDPWR.n54 585
R153 VDPWR.n61 VDPWR.n60 585
R154 VDPWR.n61 VDPWR 585
R155 VDPWR.n50 VDPWR.n49 585
R156 VDPWR.n49 VDPWR.n48 585
R157 VDPWR.n49 VDPWR.n43 585
R158 VDPWR.n49 VDPWR 585
R159 VDPWR.n38 VDPWR.n37 585
R160 VDPWR.n37 VDPWR.n36 585
R161 VDPWR.n37 VDPWR.n31 585
R162 VDPWR.n37 VDPWR 585
R163 VDPWR.n26 VDPWR.n25 585
R164 VDPWR.n25 VDPWR.n18 585
R165 VDPWR.n25 VDPWR.n24 585
R166 VDPWR.n25 VDPWR 585
R167 VDPWR.n14 VDPWR.n13 585
R168 VDPWR.n13 VDPWR.n12 585
R169 VDPWR.n13 VDPWR.n7 585
R170 VDPWR.n13 VDPWR 585
R171 VDPWR.n163 VDPWR.n162 585
R172 VDPWR.n163 VDPWR.n3 585
R173 VDPWR.n163 VDPWR.n2 585
R174 VDPWR VDPWR.n163 585
R175 VDPWR.t22 VDPWR.n146 515.487
R176 VDPWR.n130 VDPWR.n129 496.325
R177 VDPWR.t20 VDPWR.t22 456.945
R178 VDPWR.t18 VDPWR.t20 456.945
R179 VDPWR.t16 VDPWR.t14 456.945
R180 VDPWR.t14 VDPWR.t12 456.945
R181 VDPWR.t10 VDPWR.t8 456.945
R182 VDPWR.t8 VDPWR.t6 456.945
R183 VDPWR.t6 VDPWR.t4 456.945
R184 VDPWR.t4 VDPWR.t2 456.945
R185 VDPWR.t2 VDPWR.t0 456.945
R186 VDPWR.t32 VDPWR.t34 405.45
R187 VDPWR.n116 VDPWR.n115 292.476
R188 VDPWR.n138 VDPWR.n137 281.416
R189 VDPWR.n112 VDPWR.n106 280.401
R190 VDPWR.n136 VDPWR.n127 259.389
R191 VDPWR.n143 VDPWR.n111 240
R192 VDPWR.n139 VDPWR.n110 240
R193 VDPWR.n147 VDPWR.t16 229.862
R194 VDPWR.n147 VDPWR.t18 227.083
R195 VDPWR.t39 VDPWR.t41 217.619
R196 VDPWR.n13 VDPWR.n6 197.698
R197 VDPWR.n163 VDPWR.n1 197.698
R198 VDPWR.n85 VDPWR.n78 197.698
R199 VDPWR.n73 VDPWR.n66 197.698
R200 VDPWR.n25 VDPWR.n19 197.698
R201 VDPWR.n97 VDPWR.n91 197.698
R202 VDPWR.n49 VDPWR.n42 197.698
R203 VDPWR.n37 VDPWR.n30 197.698
R204 VDPWR.n61 VDPWR.n55 197.698
R205 VDPWR.t26 VDPWR.t43 192.381
R206 VDPWR.n143 VDPWR.n142 185
R207 VDPWR.n141 VDPWR.n111 185
R208 VDPWR.n140 VDPWR.n139 185
R209 VDPWR.n138 VDPWR.n110 185
R210 VDPWR.t30 VDPWR.t37 183.81
R211 VDPWR.n144 VDPWR.n110 175.21
R212 VDPWR.n144 VDPWR.n143 175.21
R213 VDPWR.n137 VDPWR.n136 170.166
R214 VDPWR.t28 VDPWR.t36 170
R215 VDPWR.t36 VDPWR.t30 143.333
R216 VDPWR.t37 VDPWR.t32 129.524
R217 VDPWR.n137 VDPWR.n126 109.382
R218 VDPWR.t43 VDPWR.n108 106.668
R219 VDPWR.n136 VDPWR.n135 103.468
R220 VDPWR.n155 VDPWR.t35 92.781
R221 VDPWR.n152 VDPWR.t23 92.2351
R222 VDPWR.n102 VDPWR.t11 92.2351
R223 VDPWR.n131 VDPWR.n130 84.778
R224 VDPWR.n142 VDPWR.n112 79.0593
R225 VDPWR.n149 VDPWR.n106 74.5185
R226 VDPWR.n111 VDPWR.n109 72.7879
R227 VDPWR.n139 VDPWR.n109 72.7879
R228 VDPWR.n132 VDPWR.n131 61.9487
R229 VDPWR.n132 VDPWR.n127 59.4678
R230 VDPWR.n145 VDPWR.n109 56.1076
R231 VDPWR.t41 VDPWR.t26 51.4291
R232 VDPWR.t24 VDPWR.t39 44.2862
R233 VDPWR.n135 VDPWR.n126 40.1093
R234 VDPWR.n129 VDPWR.n128 39.9483
R235 VDPWR.n134 VDPWR.n133 27.9709
R236 VDPWR.n117 VDPWR 25.6005
R237 VDPWR.n142 VDPWR.n141 25.6005
R238 VDPWR.n141 VDPWR.n140 25.6005
R239 VDPWR.n140 VDPWR.n138 25.6005
R240 VDPWR.n99 VDPWR.n98 25.3691
R241 VDPWR.n87 VDPWR.n86 25.3691
R242 VDPWR.n75 VDPWR.n74 25.3691
R243 VDPWR.n63 VDPWR.n62 25.3691
R244 VDPWR.n51 VDPWR.n50 25.3691
R245 VDPWR.n39 VDPWR.n38 25.3691
R246 VDPWR.n27 VDPWR.n26 25.3691
R247 VDPWR.n15 VDPWR.n14 25.3691
R248 VDPWR.n162 VDPWR.n156 25.3691
R249 VDPWR.n128 VDPWR 21.4028
R250 VDPWR.n55 VDPWR 18.8127
R251 VDPWR.n91 VDPWR 18.8127
R252 VDPWR VDPWR.n42 18.8127
R253 VDPWR VDPWR.n30 18.8127
R254 VDPWR VDPWR.n78 18.8127
R255 VDPWR VDPWR.n66 18.8127
R256 VDPWR.n19 VDPWR 18.8127
R257 VDPWR VDPWR.n6 18.8127
R258 VDPWR VDPWR.n1 18.8127
R259 VDPWR.n146 VDPWR.t24 17.1844
R260 VDPWR.n90 VDPWR.n89 16.5652
R261 VDPWR.n84 VDPWR.n77 16.5652
R262 VDPWR.n72 VDPWR.n65 16.5652
R263 VDPWR.n54 VDPWR.n53 16.5652
R264 VDPWR.n48 VDPWR.n41 16.5652
R265 VDPWR.n36 VDPWR.n29 16.5652
R266 VDPWR.n18 VDPWR.n17 16.5652
R267 VDPWR.n12 VDPWR.n5 16.5652
R268 VDPWR.n161 VDPWR.n3 16.5652
R269 VDPWR.n134 VDPWR 16.0927
R270 VDPWR.n96 VDPWR.n92 15.0593
R271 VDPWR.n83 VDPWR.n79 15.0593
R272 VDPWR.n71 VDPWR.n67 15.0593
R273 VDPWR.n60 VDPWR.n56 15.0593
R274 VDPWR.n47 VDPWR.n43 15.0593
R275 VDPWR.n35 VDPWR.n31 15.0593
R276 VDPWR.n24 VDPWR.n20 15.0593
R277 VDPWR.n11 VDPWR.n7 15.0593
R278 VDPWR.n158 VDPWR.n2 15.0593
R279 VDPWR.n146 VDPWR.n145 14.3767
R280 VDPWR.n108 VDPWR.t28 14.2862
R281 VDPWR.n116 VDPWR.t40 14.283
R282 VDPWR.n95 VDPWR 13.5534
R283 VDPWR.n80 VDPWR 13.5534
R284 VDPWR.n68 VDPWR 13.5534
R285 VDPWR.n59 VDPWR 13.5534
R286 VDPWR.n44 VDPWR 13.5534
R287 VDPWR.n32 VDPWR 13.5534
R288 VDPWR.n23 VDPWR 13.5534
R289 VDPWR.n8 VDPWR 13.5534
R290 VDPWR VDPWR.n0 13.5534
R291 VDPWR.n96 VDPWR.n95 12.0476
R292 VDPWR.n80 VDPWR.n79 12.0476
R293 VDPWR.n68 VDPWR.n67 12.0476
R294 VDPWR.n60 VDPWR.n59 12.0476
R295 VDPWR.n44 VDPWR.n43 12.0476
R296 VDPWR.n32 VDPWR.n31 12.0476
R297 VDPWR.n24 VDPWR.n23 12.0476
R298 VDPWR.n8 VDPWR.n7 12.0476
R299 VDPWR.n2 VDPWR.n0 12.0476
R300 VDPWR.n92 VDPWR.n90 10.5417
R301 VDPWR.n84 VDPWR.n83 10.5417
R302 VDPWR.n72 VDPWR.n71 10.5417
R303 VDPWR.n56 VDPWR.n54 10.5417
R304 VDPWR.n48 VDPWR.n47 10.5417
R305 VDPWR.n36 VDPWR.n35 10.5417
R306 VDPWR.n20 VDPWR.n18 10.5417
R307 VDPWR.n12 VDPWR.n11 10.5417
R308 VDPWR.n158 VDPWR.n3 10.5417
R309 VDPWR.n135 VDPWR.n134 9.95606
R310 VDPWR.n120 VDPWR.n114 9.3005
R311 VDPWR.n122 VDPWR.n121 9.3005
R312 VDPWR.n123 VDPWR.n113 9.3005
R313 VDPWR.n125 VDPWR.n124 9.3005
R314 VDPWR.n89 VDPWR.n88 9.3005
R315 VDPWR.n93 VDPWR.n92 9.3005
R316 VDPWR.n95 VDPWR.n94 9.3005
R317 VDPWR.n77 VDPWR.n76 9.3005
R318 VDPWR.n83 VDPWR.n82 9.3005
R319 VDPWR.n81 VDPWR.n80 9.3005
R320 VDPWR.n65 VDPWR.n64 9.3005
R321 VDPWR.n71 VDPWR.n70 9.3005
R322 VDPWR.n69 VDPWR.n68 9.3005
R323 VDPWR.n53 VDPWR.n52 9.3005
R324 VDPWR.n57 VDPWR.n56 9.3005
R325 VDPWR.n59 VDPWR.n58 9.3005
R326 VDPWR.n41 VDPWR.n40 9.3005
R327 VDPWR.n47 VDPWR.n46 9.3005
R328 VDPWR.n45 VDPWR.n44 9.3005
R329 VDPWR.n29 VDPWR.n28 9.3005
R330 VDPWR.n35 VDPWR.n34 9.3005
R331 VDPWR.n33 VDPWR.n32 9.3005
R332 VDPWR.n17 VDPWR.n16 9.3005
R333 VDPWR.n21 VDPWR.n20 9.3005
R334 VDPWR.n23 VDPWR.n22 9.3005
R335 VDPWR.n5 VDPWR.n4 9.3005
R336 VDPWR.n11 VDPWR.n10 9.3005
R337 VDPWR.n9 VDPWR.n8 9.3005
R338 VDPWR.n161 VDPWR.n160 9.3005
R339 VDPWR.n159 VDPWR.n158 9.3005
R340 VDPWR.n157 VDPWR.n0 9.3005
R341 VDPWR.n98 VDPWR.n89 9.03579
R342 VDPWR.n86 VDPWR.n77 9.03579
R343 VDPWR.n74 VDPWR.n65 9.03579
R344 VDPWR.n62 VDPWR.n53 9.03579
R345 VDPWR.n50 VDPWR.n41 9.03579
R346 VDPWR.n38 VDPWR.n29 9.03579
R347 VDPWR.n26 VDPWR.n17 9.03579
R348 VDPWR.n14 VDPWR.n5 9.03579
R349 VDPWR.n162 VDPWR.n161 9.03579
R350 VDPWR.n118 VDPWR.n117 8.88299
R351 VDPWR.n131 VDPWR.n128 8.11358
R352 VDPWR.n120 VDPWR.n119 7.23727
R353 VDPWR.n124 VDPWR 6.75561
R354 VDPWR.n97 VDPWR.t1 5.7135
R355 VDPWR.n85 VDPWR.t5 5.7135
R356 VDPWR.n85 VDPWR.t3 5.7135
R357 VDPWR.n73 VDPWR.t9 5.7135
R358 VDPWR.n73 VDPWR.t7 5.7135
R359 VDPWR.n61 VDPWR.t13 5.7135
R360 VDPWR.n49 VDPWR.t17 5.7135
R361 VDPWR.n49 VDPWR.t15 5.7135
R362 VDPWR.n37 VDPWR.t21 5.7135
R363 VDPWR.n37 VDPWR.t19 5.7135
R364 VDPWR.n25 VDPWR.t25 5.7135
R365 VDPWR.n13 VDPWR.t29 5.7135
R366 VDPWR.n13 VDPWR.t27 5.7135
R367 VDPWR.n163 VDPWR.t33 5.7135
R368 VDPWR.n163 VDPWR.t31 5.7135
R369 VDPWR.n125 VDPWR.n113 5.20728
R370 VDPWR.n121 VDPWR.n113 5.20728
R371 VDPWR.n121 VDPWR.n120 5.20728
R372 VDPWR.n145 VDPWR.n144 4.89628
R373 VDPWR.n118 VDPWR.n115 4.86725
R374 VDPWR.n133 VDPWR.n107 4.5127
R375 VDPWR.n108 VDPWR.n107 4.5127
R376 VDPWR.n133 VDPWR.n132 3.97871
R377 VDPWR.n119 VDPWR 3.66716
R378 VDPWR.n119 VDPWR.n112 2.83752
R379 VDPWR.n105 VDPWR 2.71026
R380 VDPWR VDPWR.n115 2.6809
R381 VDPWR.n9 VDPWR.n6 2.16295
R382 VDPWR.n157 VDPWR.n1 2.16295
R383 VDPWR.n81 VDPWR.n78 2.16293
R384 VDPWR.n69 VDPWR.n66 2.16293
R385 VDPWR.n22 VDPWR.n19 2.16293
R386 VDPWR.n94 VDPWR.n91 2.16292
R387 VDPWR.n33 VDPWR.n30 2.16292
R388 VDPWR.n45 VDPWR.n42 2.16292
R389 VDPWR.n58 VDPWR.n55 2.16292
R390 VDPWR.n126 VDPWR.n125 1.80841
R391 VDPWR.n100 VDPWR.n99 1.0348
R392 VDPWR.n149 VDPWR.n148 1.0005
R393 VDPWR.n148 VDPWR.n147 1.0005
R394 VDPWR.n102 VDPWR.n101 0.554667
R395 VDPWR.n155 VDPWR.n154 0.5505
R396 VDPWR.n154 VDPWR.n153 0.5505
R397 VDPWR.n152 VDPWR.n151 0.5505
R398 VDPWR.n104 VDPWR.n103 0.546333
R399 VDPWR.n101 VDPWR.n100 0.546333
R400 VDPWR.n100 VDPWR.n87 0.488969
R401 VDPWR.n101 VDPWR.n75 0.488969
R402 VDPWR.n103 VDPWR.n63 0.488969
R403 VDPWR.n104 VDPWR.n51 0.488969
R404 VDPWR.n151 VDPWR.n39 0.488969
R405 VDPWR.n153 VDPWR.n27 0.488969
R406 VDPWR.n154 VDPWR.n15 0.488969
R407 VDPWR.n156 VDPWR.n155 0.488969
R408 VDPWR VDPWR.n118 0.420852
R409 VDPWR.n151 VDPWR.n150 0.271333
R410 VDPWR.n105 VDPWR.n104 0.271333
R411 VDPWR.n99 VDPWR.n88 0.143564
R412 VDPWR.n87 VDPWR.n76 0.143564
R413 VDPWR.n75 VDPWR.n64 0.143564
R414 VDPWR.n63 VDPWR.n52 0.143564
R415 VDPWR.n51 VDPWR.n40 0.143564
R416 VDPWR.n39 VDPWR.n28 0.143564
R417 VDPWR.n27 VDPWR.n16 0.143564
R418 VDPWR.n15 VDPWR.n4 0.143564
R419 VDPWR.n160 VDPWR.n156 0.143564
R420 VDPWR.n93 VDPWR.n88 0.113
R421 VDPWR.n94 VDPWR.n93 0.113
R422 VDPWR.n82 VDPWR.n76 0.113
R423 VDPWR.n82 VDPWR.n81 0.113
R424 VDPWR.n70 VDPWR.n64 0.113
R425 VDPWR.n70 VDPWR.n69 0.113
R426 VDPWR.n57 VDPWR.n52 0.113
R427 VDPWR.n58 VDPWR.n57 0.113
R428 VDPWR.n46 VDPWR.n40 0.113
R429 VDPWR.n46 VDPWR.n45 0.113
R430 VDPWR.n34 VDPWR.n28 0.113
R431 VDPWR.n34 VDPWR.n33 0.113
R432 VDPWR.n21 VDPWR.n16 0.113
R433 VDPWR.n22 VDPWR.n21 0.113
R434 VDPWR.n10 VDPWR.n4 0.113
R435 VDPWR.n10 VDPWR.n9 0.113
R436 VDPWR.n160 VDPWR.n159 0.113
R437 VDPWR.n159 VDPWR.n157 0.113
R438 VDPWR.n153 VDPWR.n152 0.108833
R439 VDPWR.n103 VDPWR.n102 0.108833
R440 VDPWR.n124 VDPWR.n123 0.0534412
R441 VDPWR.n123 VDPWR.n122 0.0534412
R442 VDPWR.n122 VDPWR.n114 0.0534412
R443 VDPWR VDPWR.n114 0.0328529
R444 VDPWR.n150 VDPWR.n149 0.0272241
R445 VDPWR.n150 VDPWR.n105 0.00466667
R446 VGND.t14 VGND.n703 472233
R447 VGND.n1318 VGND.n1317 16802.3
R448 VGND.n1289 VGND.n701 13956.4
R449 VGND.n1542 VGND.n314 10498.9
R450 VGND.n1908 VGND.n140 10479.1
R451 VGND.n1543 VGND.n402 6643.2
R452 VGND.n1526 VGND.n189 4475.09
R453 VGND.n1719 VGND.n208 4278.84
R454 VGND.n1720 VGND.n1719 4278.84
R455 VGND.n1298 VGND.n1297 3342.74
R456 VGND.n296 VGND.n291 3242.67
R457 VGND.n1087 VGND.n291 3178.67
R458 VGND.n1678 VGND.n296 3136
R459 VGND.n1678 VGND.n402 3093.33
R460 VGND.n1088 VGND.n1087 2752.62
R461 VGND.n1089 VGND.n1088 2024.28
R462 VGND.n1089 VGND.n692 1825.1
R463 VGND.n1878 VGND.n189 1578.57
R464 VGND.n1726 VGND.n305 1221.1
R465 VGND.n1317 VGND.n1316 1170
R466 VGND.n1750 VGND.n1749 1007.63
R467 VGND.n1749 VGND.n1748 1007.63
R468 VGND.n1748 VGND.n294 1007.63
R469 VGND.n1742 VGND.n294 1007.63
R470 VGND.n1742 VGND.n1741 1007.63
R471 VGND.n1735 VGND.n300 1007.63
R472 VGND.n1735 VGND.n1734 1007.63
R473 VGND.n1734 VGND.n1733 1007.63
R474 VGND.n1733 VGND.n301 1007.63
R475 VGND.n1727 VGND.n301 1007.63
R476 VGND.n1076 VGND.n1075 1007.63
R477 VGND.n1076 VGND.n944 1007.63
R478 VGND.n1082 VGND.n944 1007.63
R479 VGND.n1083 VGND.n1082 1007.63
R480 VGND.n1084 VGND.n1083 1007.63
R481 VGND.n942 VGND.n941 1007.63
R482 VGND.n941 VGND.n940 1007.63
R483 VGND.n940 VGND.n925 1007.63
R484 VGND.n934 VGND.n925 1007.63
R485 VGND.n934 VGND.n933 1007.63
R486 VGND.n1683 VGND.n305 968.808
R487 VGND.n1646 VGND.n432 908.258
R488 VGND.n1647 VGND.n1646 908.258
R489 VGND.n1647 VGND.n426 908.258
R490 VGND.n1653 VGND.n426 908.258
R491 VGND.n1654 VGND.n1653 908.258
R492 VGND.n422 VGND.n416 908.258
R493 VGND.n1668 VGND.n416 908.258
R494 VGND.n1668 VGND.n408 908.258
R495 VGND.n1682 VGND.n408 908.258
R496 VGND.n1683 VGND.n1682 908.258
R497 VGND.n2032 VGND.n117 876.106
R498 VGND.n124 VGND.n117 876.106
R499 VGND.n2025 VGND.n124 876.106
R500 VGND.n2025 VGND.n2024 876.106
R501 VGND.n2024 VGND.n2023 876.106
R502 VGND.n2017 VGND.n132 876.106
R503 VGND.n2017 VGND.n2016 876.106
R504 VGND.n2016 VGND.n2015 876.106
R505 VGND.n2015 VGND.n135 876.106
R506 VGND.n2008 VGND.n135 876.106
R507 VGND.n1119 VGND.n892 872.247
R508 VGND.n1125 VGND.n892 872.247
R509 VGND.n1126 VGND.n1125 872.247
R510 VGND.n1126 VGND.n888 872.247
R511 VGND.n1132 VGND.n888 872.247
R512 VGND.n1134 VGND.n883 872.247
R513 VGND.n1140 VGND.n883 872.247
R514 VGND.n1141 VGND.n1140 872.247
R515 VGND.n1141 VGND.n879 872.247
R516 VGND.n1147 VGND.n879 872.247
R517 VGND.n1542 VGND.n189 759.029
R518 VGND.n300 VGND.t29 682.952
R519 VGND.n942 VGND.t31 682.952
R520 VGND.t17 VGND.t21 663.014
R521 VGND.n0 VGND.t29 2.97516
R522 VGND.t16 VGND.t17 657.534
R523 VGND.n216 VGND.n2 1.98592
R524 VGND.n1558 VGND.n216 638.298
R525 VGND.n1215 VGND.n876 629.801
R526 VGND.n1215 VGND.n739 602.707
R527 VGND.n132 VGND.t36 593.806
R528 VGND.n1289 VGND.t14 593.664
R529 VGND.n1134 VGND.t31 591.189
R530 VGND.n1288 VGND.n702 586.866
R531 VGND.n1287 VGND.n701 585.47
R532 VGND.n701 VGND.n699 585
R533 VGND.n1285 VGND.n1284 585
R534 VGND.n1286 VGND.n1285 585
R535 VGND.n718 VGND.n707 585
R536 VGND.n707 VGND.n706 585
R537 VGND.n717 VGND.n716 585
R538 VGND.n716 VGND.n705 585
R539 VGND.n715 VGND.n714 585
R540 VGND.n715 VGND.n704 585
R541 VGND.n711 VGND.n702 585
R542 VGND.n1290 VGND.n1289 585
R543 VGND.n981 VGND.n959 585
R544 VGND.n980 VGND.n968 585
R545 VGND.n1001 VGND.n969 585
R546 VGND.n1000 VGND.n970 585
R547 VGND.n999 VGND.n971 585
R548 VGND.n996 VGND.n972 585
R549 VGND.n995 VGND.n973 585
R550 VGND.n992 VGND.n974 585
R551 VGND.n991 VGND.n975 585
R552 VGND.n988 VGND.n986 585
R553 VGND.n1043 VGND.n1042 585
R554 VGND.n1044 VGND.n1043 585
R555 VGND.n1757 VGND.n265 585
R556 VGND.n281 VGND.n264 585
R557 VGND.n287 VGND.n283 585
R558 VGND.n280 VGND.n279 585
R559 VGND.n276 VGND.n275 585
R560 VGND.n274 VGND.n244 585
R561 VGND.n1816 VGND.n243 585
R562 VGND.n1820 VGND.n238 585
R563 VGND.n234 VGND.n233 585
R564 VGND.n1826 VGND.n1825 585
R565 VGND.n1757 VGND.n1756 585
R566 VGND.n289 VGND.n264 585
R567 VGND.n288 VGND.n287 585
R568 VGND.n279 VGND.n278 585
R569 VGND.n277 VGND.n276 585
R570 VGND.n244 VGND.n242 585
R571 VGND.n1817 VGND.n1816 585
R572 VGND.n1820 VGND.n1819 585
R573 VGND.n241 VGND.n234 585
R574 VGND.n1825 VGND.n229 585
R575 VGND.n1680 VGND.n407 585
R576 VGND.n1682 VGND.n407 585
R577 VGND.n1671 VGND.n1670 585
R578 VGND.n1670 VGND.n408 585
R579 VGND.n1669 VGND.n414 585
R580 VGND.n1669 VGND.n1668 585
R581 VGND.n1665 VGND.n415 585
R582 VGND.n416 VGND.n415 585
R583 VGND.n423 VGND.n421 585
R584 VGND.n423 VGND.n422 585
R585 VGND.n1656 VGND.n424 585
R586 VGND.n1654 VGND.n424 585
R587 VGND.n1652 VGND.n420 585
R588 VGND.n1653 VGND.n1652 585
R589 VGND.n1651 VGND.n1650 585
R590 VGND.n1651 VGND.n426 585
R591 VGND.n431 VGND.n427 585
R592 VGND.n1647 VGND.n427 585
R593 VGND.n1645 VGND.n1644 585
R594 VGND.n1646 VGND.n1645 585
R595 VGND.n1681 VGND.n1680 585
R596 VGND.n1682 VGND.n1681 585
R597 VGND.n1671 VGND.n409 585
R598 VGND.n409 VGND.n408 585
R599 VGND.n1667 VGND.n414 585
R600 VGND.n1668 VGND.n1667 585
R601 VGND.n1666 VGND.n1665 585
R602 VGND.n1666 VGND.n416 585
R603 VGND.n421 VGND.n417 585
R604 VGND.n422 VGND.n417 585
R605 VGND.n1656 VGND.n1655 585
R606 VGND.n1655 VGND.n1654 585
R607 VGND.n425 VGND.n420 585
R608 VGND.n1653 VGND.n425 585
R609 VGND.n1650 VGND.n1649 585
R610 VGND.n1649 VGND.n426 585
R611 VGND.n1648 VGND.n431 585
R612 VGND.n1648 VGND.n1647 585
R613 VGND.n1644 VGND.n430 585
R614 VGND.n1646 VGND.n430 585
R615 VGND.n205 VGND.n201 585
R616 VGND.n1874 VGND.n1873 585
R617 VGND.n633 VGND.n200 585
R618 VGND.n639 VGND.n638 585
R619 VGND.n645 VGND.n644 585
R620 VGND.n643 VGND.n543 585
R621 VGND.n655 VGND.n654 585
R622 VGND.n653 VGND.n652 585
R623 VGND.n669 VGND.n668 585
R624 VGND.n667 VGND.n666 585
R625 VGND.n1862 VGND.n1861 585
R626 VGND.n212 VGND.n211 585
R627 VGND.n1855 VGND.n1854 585
R628 VGND.n1852 VGND.n223 585
R629 VGND.n1850 VGND.n1849 585
R630 VGND.n1846 VGND.n224 585
R631 VGND.n1845 VGND.n1842 585
R632 VGND.n1840 VGND.n225 585
R633 VGND.n1838 VGND.n1837 585
R634 VGND.n1834 VGND.n227 585
R635 VGND.n1833 VGND.n61 585
R636 VGND.n1833 VGND.n1832 585
R637 VGND.n1835 VGND.n1834 585
R638 VGND.n1837 VGND.n1836 585
R639 VGND.n1843 VGND.n225 585
R640 VGND.n1845 VGND.n1844 585
R641 VGND.n1847 VGND.n1846 585
R642 VGND.n1849 VGND.n1848 585
R643 VGND.n223 VGND.n222 585
R644 VGND.n1856 VGND.n1855 585
R645 VGND.n214 VGND.n212 585
R646 VGND.n1861 VGND.n1860 585
R647 VGND.n60 VGND.n57 585
R648 VGND.n2060 VGND.n2059 585
R649 VGND.n2059 VGND.n2058 585
R650 VGND.n1830 VGND.n1829 585
R651 VGND.n1830 VGND.n28 585
R652 VGND.n230 VGND.n64 585
R653 VGND.n2058 VGND.n64 585
R654 VGND.n985 VGND.n230 585
R655 VGND.n232 VGND.n230 585
R656 VGND.n1829 VGND.n1828 585
R657 VGND.n1004 VGND.n56 585
R658 VGND.n989 VGND.n988 585
R659 VGND.n991 VGND.n990 585
R660 VGND.n993 VGND.n992 585
R661 VGND.n995 VGND.n994 585
R662 VGND.n997 VGND.n996 585
R663 VGND.n999 VGND.n998 585
R664 VGND.n1000 VGND.n967 585
R665 VGND.n1002 VGND.n1001 585
R666 VGND.n968 VGND.n961 585
R667 VGND.n1005 VGND.n959 585
R668 VGND.n1005 VGND.n1004 585
R669 VGND.n2062 VGND.n2061 585
R670 VGND.n1035 VGND.n960 585
R671 VGND.n1039 VGND.n960 585
R672 VGND.n1037 VGND.n1036 585
R673 VGND.n1038 VGND.n1037 585
R674 VGND.n1034 VGND.n1007 585
R675 VGND.n1007 VGND.n1006 585
R676 VGND.n1033 VGND.n1032 585
R677 VGND.n1032 VGND.n1031 585
R678 VGND.n1009 VGND.n1008 585
R679 VGND.n1030 VGND.n1009 585
R680 VGND.n1028 VGND.n1027 585
R681 VGND.n1029 VGND.n1028 585
R682 VGND.n1026 VGND.n1010 585
R683 VGND.n1022 VGND.n1010 585
R684 VGND.n1025 VGND.n1024 585
R685 VGND.n1024 VGND.n1023 585
R686 VGND.n1012 VGND.n1011 585
R687 VGND.n1021 VGND.n1012 585
R688 VGND.n1019 VGND.n1018 585
R689 VGND.n1020 VGND.n1019 585
R690 VGND.n1017 VGND.n1014 585
R691 VGND.n1014 VGND.n1013 585
R692 VGND.n1016 VGND.n1015 585
R693 VGND.n1015 VGND.n896 585
R694 VGND.n1042 VGND.n1041 585
R695 VGND.n1041 VGND.n1040 585
R696 VGND.n1116 VGND.n1115 585
R697 VGND.n1117 VGND.n1116 585
R698 VGND.n1120 VGND.n894 585
R699 VGND.n1120 VGND.n1119 585
R700 VGND.n1122 VGND.n1121 585
R701 VGND.n1121 VGND.n892 585
R702 VGND.n891 VGND.n890 585
R703 VGND.n1125 VGND.n891 585
R704 VGND.n1128 VGND.n1127 585
R705 VGND.n1127 VGND.n1126 585
R706 VGND.n1129 VGND.n886 585
R707 VGND.n888 VGND.n886 585
R708 VGND.n1133 VGND.n887 585
R709 VGND.n1133 VGND.n1132 585
R710 VGND.n1135 VGND.n885 585
R711 VGND.n1135 VGND.n1134 585
R712 VGND.n1137 VGND.n1136 585
R713 VGND.n1136 VGND.n883 585
R714 VGND.n882 VGND.n881 585
R715 VGND.n1140 VGND.n882 585
R716 VGND.n1143 VGND.n1142 585
R717 VGND.n1142 VGND.n1141 585
R718 VGND.n1115 VGND.n1114 585
R719 VGND.n1114 VGND.n1113 585
R720 VGND.n1143 VGND.n880 585
R721 VGND.n1141 VGND.n880 585
R722 VGND.n1139 VGND.n881 585
R723 VGND.n1140 VGND.n1139 585
R724 VGND.n1138 VGND.n1137 585
R725 VGND.n1138 VGND.n883 585
R726 VGND.n885 VGND.n884 585
R727 VGND.n1134 VGND.n884 585
R728 VGND.n1131 VGND.n887 585
R729 VGND.n1132 VGND.n1131 585
R730 VGND.n1130 VGND.n1129 585
R731 VGND.n1130 VGND.n888 585
R732 VGND.n1128 VGND.n889 585
R733 VGND.n1126 VGND.n889 585
R734 VGND.n1124 VGND.n890 585
R735 VGND.n1125 VGND.n1124 585
R736 VGND.n1123 VGND.n1122 585
R737 VGND.n1123 VGND.n892 585
R738 VGND.n894 VGND.n893 585
R739 VGND.n1119 VGND.n893 585
R740 VGND.n874 VGND.n873 585
R741 VGND.n1224 VGND.n1223 585
R742 VGND.n1222 VGND.n1221 585
R743 VGND.n816 VGND.n815 585
R744 VGND.n814 VGND.n813 585
R745 VGND.n1238 VGND.n1237 585
R746 VGND.n1236 VGND.n1235 585
R747 VGND.n806 VGND.n744 585
R748 VGND.n1256 VGND.n1255 585
R749 VGND.n768 VGND.n738 585
R750 VGND.n1258 VGND.n739 585
R751 VGND.n824 VGND.n819 585
R752 VGND.n1226 VGND.n1225 585
R753 VGND.n1228 VGND.n818 585
R754 VGND.n1230 VGND.n1229 585
R755 VGND.n812 VGND.n809 585
R756 VGND.n1240 VGND.n1239 585
R757 VGND.n1242 VGND.n808 585
R758 VGND.n1243 VGND.n746 585
R759 VGND.n1245 VGND.n745 585
R760 VGND.n1247 VGND.n1246 585
R761 VGND.n1455 VGND.n1331 585
R762 VGND.n1457 VGND.n1456 585
R763 VGND.n1427 VGND.n1426 585
R764 VGND.n1429 VGND.n1428 585
R765 VGND.n1419 VGND.n1418 585
R766 VGND.n1417 VGND.n1416 585
R767 VGND.n1442 VGND.n1441 585
R768 VGND.n1444 VGND.n1443 585
R769 VGND.n1344 VGND.n1343 585
R770 VGND.n1451 VGND.n1450 585
R771 VGND.n1467 VGND.n1466 585
R772 VGND.n1338 VGND.n1330 585
R773 VGND.n1337 VGND.n1336 585
R774 VGND.n1424 VGND.n1423 585
R775 VGND.n1422 VGND.n1421 585
R776 VGND.n1438 VGND.n1437 585
R777 VGND.n1440 VGND.n1439 585
R778 VGND.n1413 VGND.n1412 585
R779 VGND.n1411 VGND.n1410 585
R780 VGND.n1449 VGND.n1325 585
R781 VGND.n1481 VGND.n1480 585
R782 VGND.n1480 VGND.n1479 585
R783 VGND.n1482 VGND.n683 585
R784 VGND.n683 VGND.n682 585
R785 VGND.n1484 VGND.n1483 585
R786 VGND.n1485 VGND.n1484 585
R787 VGND.n680 VGND.n678 585
R788 VGND.n1486 VGND.n680 585
R789 VGND.n1511 VGND.n1510 585
R790 VGND.n1510 VGND.n1509 585
R791 VGND.n681 VGND.n679 585
R792 VGND.n1508 VGND.n681 585
R793 VGND.n1506 VGND.n1505 585
R794 VGND.n1507 VGND.n1506 585
R795 VGND.n1504 VGND.n1488 585
R796 VGND.n1488 VGND.n1487 585
R797 VGND.n1503 VGND.n1502 585
R798 VGND.n1502 VGND.n1501 585
R799 VGND.n1490 VGND.n1489 585
R800 VGND.n1500 VGND.n1490 585
R801 VGND.n1498 VGND.n1497 585
R802 VGND.n1499 VGND.n1498 585
R803 VGND.n1471 VGND.n1470 585
R804 VGND.n1470 VGND.n1469 585
R805 VGND.n1477 VGND.n684 585
R806 VGND.n1478 VGND.n1477 585
R807 VGND.n1475 VGND.n1474 585
R808 VGND.n1476 VGND.n1475 585
R809 VGND.n1473 VGND.n688 585
R810 VGND.n796 VGND.n770 585
R811 VGND.n797 VGND.n796 585
R812 VGND.n795 VGND.n794 585
R813 VGND.n795 VGND.n771 585
R814 VGND.n793 VGND.n772 585
R815 VGND.n779 VGND.n772 585
R816 VGND.n792 VGND.n791 585
R817 VGND.n791 VGND.n790 585
R818 VGND.n782 VGND.n778 585
R819 VGND.n789 VGND.n778 585
R820 VGND.n787 VGND.n786 585
R821 VGND.n788 VGND.n787 585
R822 VGND.n785 VGND.n781 585
R823 VGND.n781 VGND.n780 585
R824 VGND.n784 VGND.n783 585
R825 VGND.n783 VGND.n691 585
R826 VGND.n690 VGND.n689 585
R827 VGND.n1319 VGND.n690 585
R828 VGND.n1322 VGND.n1321 585
R829 VGND.n1321 VGND.n1320 585
R830 VGND.n1323 VGND.n687 585
R831 VGND.n687 VGND.n686 585
R832 VGND.n802 VGND.n801 585
R833 VGND.n800 VGND.n799 585
R834 VGND.n799 VGND.n798 585
R835 VGND.n1263 VGND.n1262 585
R836 VGND.n1264 VGND.n1263 585
R837 VGND.n1261 VGND.n736 585
R838 VGND.n736 VGND.n735 585
R839 VGND.n1260 VGND.n1259 585
R840 VGND.n1259 VGND.n1258 585
R841 VGND.n729 VGND.n723 585
R842 VGND.n1274 VGND.n729 585
R843 VGND.n1272 VGND.n1271 585
R844 VGND.n1273 VGND.n1272 585
R845 VGND.n1270 VGND.n732 585
R846 VGND.n732 VGND.n731 585
R847 VGND.n1268 VGND.n1267 585
R848 VGND.n1267 VGND.n1266 585
R849 VGND.n734 VGND.n733 585
R850 VGND.n1265 VGND.n734 585
R851 VGND.n1277 VGND.n724 585
R852 VGND.n908 VGND.n724 585
R853 VGND.n914 VGND.n913 585
R854 VGND.n912 VGND.n911 585
R855 VGND.n910 VGND.n909 585
R856 VGND.n730 VGND.n728 585
R857 VGND.n1277 VGND.n1276 585
R858 VGND.n1276 VGND.n1275 585
R859 VGND.n1108 VGND.n898 585
R860 VGND.n1112 VGND.n898 585
R861 VGND.n1110 VGND.n1109 585
R862 VGND.n1111 VGND.n1110 585
R863 VGND.n1107 VGND.n900 585
R864 VGND.n900 VGND.n899 585
R865 VGND.n1106 VGND.n1105 585
R866 VGND.n1105 VGND.n1104 585
R867 VGND.n902 VGND.n901 585
R868 VGND.n1103 VGND.n902 585
R869 VGND.n1101 VGND.n1100 585
R870 VGND.n1102 VGND.n1101 585
R871 VGND.n1099 VGND.n903 585
R872 VGND.n1095 VGND.n903 585
R873 VGND.n1098 VGND.n1097 585
R874 VGND.n1097 VGND.n1096 585
R875 VGND.n905 VGND.n904 585
R876 VGND.n1094 VGND.n905 585
R877 VGND.n1092 VGND.n1091 585
R878 VGND.n1093 VGND.n1092 585
R879 VGND.n919 VGND.n918 585
R880 VGND.n918 VGND.n906 585
R881 VGND.n917 VGND.n725 585
R882 VGND.n917 VGND.n916 585
R883 VGND.n1067 VGND.n947 585
R884 VGND.n1071 VGND.n947 585
R885 VGND.n1069 VGND.n1068 585
R886 VGND.n1070 VGND.n1069 585
R887 VGND.n1066 VGND.n949 585
R888 VGND.n1062 VGND.n949 585
R889 VGND.n1065 VGND.n1064 585
R890 VGND.n1064 VGND.n1063 585
R891 VGND.n951 VGND.n950 585
R892 VGND.n1061 VGND.n951 585
R893 VGND.n1059 VGND.n1058 585
R894 VGND.n1060 VGND.n1059 585
R895 VGND.n1057 VGND.n952 585
R896 VGND.n1053 VGND.n952 585
R897 VGND.n1056 VGND.n1055 585
R898 VGND.n1055 VGND.n1054 585
R899 VGND.n954 VGND.n953 585
R900 VGND.n1052 VGND.n954 585
R901 VGND.n1050 VGND.n1049 585
R902 VGND.n1051 VGND.n1050 585
R903 VGND.n1048 VGND.n956 585
R904 VGND.n956 VGND.n955 585
R905 VGND.n1047 VGND.n1046 585
R906 VGND.n1046 VGND.n1045 585
R907 VGND.n1073 VGND.n948 585
R908 VGND.n1073 VGND.n1072 585
R909 VGND.n937 VGND.n926 585
R910 VGND.n926 VGND.n925 585
R911 VGND.n939 VGND.n938 585
R912 VGND.n940 VGND.n939 585
R913 VGND.n927 VGND.n924 585
R914 VGND.n941 VGND.n924 585
R915 VGND.n943 VGND.n922 585
R916 VGND.n943 VGND.n942 585
R917 VGND.n1086 VGND.n1085 585
R918 VGND.n1085 VGND.n1084 585
R919 VGND.n923 VGND.n921 585
R920 VGND.n1083 VGND.n923 585
R921 VGND.n1081 VGND.n1080 585
R922 VGND.n1082 VGND.n1081 585
R923 VGND.n1079 VGND.n945 585
R924 VGND.n945 VGND.n944 585
R925 VGND.n1078 VGND.n1077 585
R926 VGND.n1077 VGND.n1076 585
R927 VGND.n1074 VGND.n946 585
R928 VGND.n1075 VGND.n1074 585
R929 VGND.n1755 VGND.n1754 585
R930 VGND.n1755 VGND.n28 585
R931 VGND.n1753 VGND.n63 585
R932 VGND.n2058 VGND.n63 585
R933 VGND.n932 VGND.n928 585
R934 VGND.n933 VGND.n932 585
R935 VGND.n936 VGND.n935 585
R936 VGND.n935 VGND.n934 585
R937 VGND.n931 VGND.n930 585
R938 VGND.n1730 VGND.n302 585
R939 VGND.n302 VGND.n301 585
R940 VGND.n1732 VGND.n1731 585
R941 VGND.n1733 VGND.n1732 585
R942 VGND.n299 VGND.n298 585
R943 VGND.n1734 VGND.n299 585
R944 VGND.n1737 VGND.n1736 585
R945 VGND.n1736 VGND.n1735 585
R946 VGND.n1738 VGND.n297 585
R947 VGND.n300 VGND.n297 585
R948 VGND.n1740 VGND.n1739 585
R949 VGND.n1741 VGND.n1740 585
R950 VGND.n1744 VGND.n1743 585
R951 VGND.n1743 VGND.n1742 585
R952 VGND.n1745 VGND.n295 585
R953 VGND.n295 VGND.n294 585
R954 VGND.n1747 VGND.n1746 585
R955 VGND.n1748 VGND.n1747 585
R956 VGND.n293 VGND.n292 585
R957 VGND.n1749 VGND.n293 585
R958 VGND.n1752 VGND.n1751 585
R959 VGND.n1751 VGND.n1750 585
R960 VGND.n1684 VGND.n406 585
R961 VGND.n1684 VGND.n1683 585
R962 VGND.n1686 VGND.n1685 585
R963 VGND.n1685 VGND.n305 585
R964 VGND.n1729 VGND.n1728 585
R965 VGND.n1728 VGND.n1727 585
R966 VGND.n304 VGND.n303 585
R967 VGND.n1683 VGND.n304 585
R968 VGND.n1707 VGND.n309 585
R969 VGND.n1706 VGND.n1705 585
R970 VGND.n1703 VGND.n400 585
R971 VGND.n1701 VGND.n1700 585
R972 VGND.n1699 VGND.n401 585
R973 VGND.n1698 VGND.n1697 585
R974 VGND.n1695 VGND.n1694 585
R975 VGND.n1693 VGND.n1692 585
R976 VGND.n1691 VGND.n404 585
R977 VGND.n1689 VGND.n1688 585
R978 VGND.n1687 VGND.n405 585
R979 VGND.n405 VGND.n306 585
R980 VGND.n1722 VGND.n312 585
R981 VGND.n1723 VGND.n1722 585
R982 VGND.n1723 VGND.n306 585
R983 VGND.n1725 VGND.n1724 585
R984 VGND.n1546 VGND.n307 585
R985 VGND.n1548 VGND.n1547 585
R986 VGND.n1550 VGND.n1549 585
R987 VGND.n1551 VGND.n448 585
R988 VGND.n1554 VGND.n1553 585
R989 VGND.n449 VGND.n447 585
R990 VGND.n461 VGND.n460 585
R991 VGND.n459 VGND.n452 585
R992 VGND.n458 VGND.n457 585
R993 VGND.n456 VGND.n455 585
R994 VGND.n454 VGND.n453 585
R995 VGND.n1570 VGND.n435 585
R996 VGND.n1556 VGND.n436 585
R997 VGND.n1555 VGND.n438 585
R998 VGND.n1558 VGND.n1555 585
R999 VGND.n1563 VGND.n441 585
R1000 VGND.n1562 VGND.n442 585
R1001 VGND.n1561 VGND.n1560 585
R1002 VGND.n443 VGND.n316 585
R1003 VGND.n1715 VGND.n318 585
R1004 VGND.n1714 VGND.n319 585
R1005 VGND.n1713 VGND.n320 585
R1006 VGND.n1558 VGND.n320 585
R1007 VGND.n1709 VGND.n321 585
R1008 VGND.n1574 VGND.n433 585
R1009 VGND.n433 VGND.n432 585
R1010 VGND.n1572 VGND.n217 585
R1011 VGND.n1858 VGND.n217 585
R1012 VGND.n1866 VGND.n1865 585
R1013 VGND.n1864 VGND.n209 585
R1014 VGND.n1572 VGND.n215 585
R1015 VGND.n1574 VGND.n1573 585
R1016 VGND.n1573 VGND.n432 585
R1017 VGND.n437 VGND.n210 585
R1018 VGND.n1722 VGND.n1721 585
R1019 VGND.n1711 VGND.n1709 585
R1020 VGND.n1713 VGND.n1712 585
R1021 VGND.n1714 VGND.n317 585
R1022 VGND.n1716 VGND.n1715 585
R1023 VGND.n1718 VGND.n316 585
R1024 VGND.n1561 VGND.n315 585
R1025 VGND.n1562 VGND.n440 585
R1026 VGND.n1564 VGND.n1563 585
R1027 VGND.n1566 VGND.n438 585
R1028 VGND.n1567 VGND.n436 585
R1029 VGND.n1570 VGND.n1569 585
R1030 VGND.n1537 VGND.n467 585
R1031 VGND.n467 VGND.n465 585
R1032 VGND.n1868 VGND.n1867 585
R1033 VGND.n1870 VGND.n206 585
R1034 VGND.n1872 VGND.n1871 585
R1035 VGND.n635 VGND.n634 585
R1036 VGND.n637 VGND.n636 585
R1037 VGND.n642 VGND.n628 585
R1038 VGND.n648 VGND.n647 585
R1039 VGND.n650 VGND.n542 585
R1040 VGND.n658 VGND.n657 585
R1041 VGND.n660 VGND.n565 585
R1042 VGND.n661 VGND.n564 585
R1043 VGND.n175 VGND.n139 585
R1044 VGND.n175 VGND.n173 585
R1045 VGND.n1525 VGND.n537 585
R1046 VGND.n1527 VGND.n1525 585
R1047 VGND.n1524 VGND.n1523 585
R1048 VGND.n1524 VGND.n192 585
R1049 VGND.n1519 VGND.n541 585
R1050 VGND.n541 VGND.n191 585
R1051 VGND.n1515 VGND.n182 585
R1052 VGND.n184 VGND.n182 585
R1053 VGND.n1899 VGND.n1898 585
R1054 VGND.n1898 VGND.n1897 585
R1055 VGND.n178 VGND.n176 585
R1056 VGND.n1883 VGND.n176 585
R1057 VGND.n1905 VGND.n1904 585
R1058 VGND.n1906 VGND.n1905 585
R1059 VGND.n1540 VGND.n1539 585
R1060 VGND.n1541 VGND.n1540 585
R1061 VGND.n538 VGND.n466 585
R1062 VGND.n466 VGND.n464 585
R1063 VGND.n1530 VGND.n1529 585
R1064 VGND.n1529 VGND.n1528 585
R1065 VGND.n1879 VGND.n1878 585
R1066 VGND.n1878 VGND.n1877 585
R1067 VGND.n1893 VGND.n186 585
R1068 VGND.n190 VGND.n186 585
R1069 VGND.n1895 VGND.n1894 585
R1070 VGND.n1896 VGND.n1895 585
R1071 VGND.n1887 VGND.n185 585
R1072 VGND.n185 VGND.n183 585
R1073 VGND.n1886 VGND.n1885 585
R1074 VGND.n1885 VGND.n1884 585
R1075 VGND.n1881 VGND.n172 585
R1076 VGND.n174 VGND.n172 585
R1077 VGND.n1909 VGND.n1908 585
R1078 VGND.n1908 VGND.n1907 585
R1079 VGND.n1496 VGND.n1492 585
R1080 VGND.n1492 VGND.n1491 585
R1081 VGND.n2007 VGND.n138 585
R1082 VGND.n2008 VGND.n2007 585
R1083 VGND.n2006 VGND.n2005 585
R1084 VGND.n2004 VGND.n2003 585
R1085 VGND.n2002 VGND.n2001 585
R1086 VGND.n1920 VGND.n144 585
R1087 VGND.n1981 VGND.n1980 585
R1088 VGND.n1983 VGND.n1919 585
R1089 VGND.n1985 VGND.n1984 585
R1090 VGND.n170 VGND.n169 585
R1091 VGND.n1991 VGND.n1990 585
R1092 VGND.n1994 VGND.n1993 585
R1093 VGND.n167 VGND.n165 585
R1094 VGND.n1495 VGND.n1494 585
R1095 VGND.n2010 VGND.n2009 585
R1096 VGND.n2009 VGND.n2008 585
R1097 VGND.n2012 VGND.n137 585
R1098 VGND.n137 VGND.n135 585
R1099 VGND.n2013 VGND.n134 585
R1100 VGND.n2015 VGND.n134 585
R1101 VGND.n133 VGND.n130 585
R1102 VGND.n2016 VGND.n133 585
R1103 VGND.n2019 VGND.n129 585
R1104 VGND.n2017 VGND.n129 585
R1105 VGND.n2020 VGND.n128 585
R1106 VGND.n132 VGND.n128 585
R1107 VGND.n2021 VGND.n126 585
R1108 VGND.n2023 VGND.n126 585
R1109 VGND.n125 VGND.n122 585
R1110 VGND.n2024 VGND.n125 585
R1111 VGND.n2027 VGND.n121 585
R1112 VGND.n2025 VGND.n121 585
R1113 VGND.n2028 VGND.n120 585
R1114 VGND.n124 VGND.n120 585
R1115 VGND.n2029 VGND.n115 585
R1116 VGND.n117 VGND.n115 585
R1117 VGND.n2033 VGND.n116 585
R1118 VGND.n2033 VGND.n2032 585
R1119 VGND.n2031 VGND.n116 585
R1120 VGND.n2032 VGND.n2031 585
R1121 VGND.n2030 VGND.n2029 585
R1122 VGND.n2030 VGND.n117 585
R1123 VGND.n2028 VGND.n119 585
R1124 VGND.n124 VGND.n119 585
R1125 VGND.n2027 VGND.n2026 585
R1126 VGND.n2026 VGND.n2025 585
R1127 VGND.n123 VGND.n122 585
R1128 VGND.n2024 VGND.n123 585
R1129 VGND.n2022 VGND.n2021 585
R1130 VGND.n2023 VGND.n2022 585
R1131 VGND.n2020 VGND.n127 585
R1132 VGND.n132 VGND.n127 585
R1133 VGND.n2019 VGND.n2018 585
R1134 VGND.n2018 VGND.n2017 585
R1135 VGND.n131 VGND.n130 585
R1136 VGND.n2016 VGND.n131 585
R1137 VGND.n2014 VGND.n2013 585
R1138 VGND.n2015 VGND.n2014 585
R1139 VGND.n2012 VGND.n136 585
R1140 VGND.n136 VGND.n135 585
R1141 VGND.n114 VGND.n110 585
R1142 VGND.n1469 VGND.n114 585
R1143 VGND.n2036 VGND.n2035 585
R1144 VGND.n2035 VGND.n2034 585
R1145 VGND.n664 VGND.n663 585
R1146 VGND.n622 VGND.n621 585
R1147 VGND.n621 VGND.n75 585
R1148 VGND.n2038 VGND.n2037 585
R1149 VGND.n1464 VGND.n109 585
R1150 VGND.n625 VGND.n624 585
R1151 VGND.n627 VGND.n626 585
R1152 VGND.n2040 VGND.n108 585
R1153 VGND.n2042 VGND.n2041 585
R1154 VGND.n106 VGND.n81 585
R1155 VGND.n105 VGND.n104 585
R1156 VGND.n96 VGND.n84 585
R1157 VGND.n98 VGND.n97 585
R1158 VGND.n94 VGND.n93 585
R1159 VGND.n89 VGND.n87 585
R1160 VGND.n71 VGND.n70 585
R1161 VGND.n2052 VGND.n2051 585
R1162 VGND.n2055 VGND.n2054 585
R1163 VGND.n2047 VGND.n67 585
R1164 VGND.n2050 VGND.n2049 585
R1165 VGND.n88 VGND.n72 585
R1166 VGND.n92 VGND.n91 585
R1167 VGND.n90 VGND.n85 585
R1168 VGND.n100 VGND.n99 585
R1169 VGND.n102 VGND.n101 585
R1170 VGND.n103 VGND.n80 585
R1171 VGND.n2044 VGND.n2043 585
R1172 VGND.n82 VGND.n79 585
R1173 VGND.n112 VGND.n111 585
R1174 VGND.n68 VGND.n66 585
R1175 VGND.n68 VGND.n62 585
R1176 VGND.n1156 VGND.n1155 585
R1177 VGND.n2057 VGND.n2056 585
R1178 VGND.n2058 VGND.n2057 585
R1179 VGND.n1146 VGND.n877 585
R1180 VGND.n1147 VGND.n1146 585
R1181 VGND.n1145 VGND.n1144 585
R1182 VGND.n1145 VGND.n879 585
R1183 VGND.n1144 VGND.n878 585
R1184 VGND.n879 VGND.n878 585
R1185 VGND.n1148 VGND.n877 585
R1186 VGND.n1148 VGND.n1147 585
R1187 VGND.n1153 VGND.n1152 585
R1188 VGND.n54 VGND.n43 585
R1189 VGND.n2068 VGND.n2067 585
R1190 VGND.n2070 VGND.n42 585
R1191 VGND.n2071 VGND.n4 585
R1192 VGND.n2074 VGND.n2073 585
R1193 VGND.n41 VGND.n39 585
R1194 VGND.n773 VGND.n29 585
R1195 VGND.n2083 VGND.n2082 585
R1196 VGND.n2086 VGND.n2085 585
R1197 VGND.n1212 VGND.n27 585
R1198 VGND.n2064 VGND.n55 585
R1199 VGND.n2066 VGND.n2065 585
R1200 VGND.n52 VGND.n51 585
R1201 VGND.n50 VGND.n49 585
R1202 VGND.n35 VGND.n3 585
R1203 VGND.n2077 VGND.n2076 585
R1204 VGND.n2079 VGND.n33 585
R1205 VGND.n2081 VGND.n2080 585
R1206 VGND.n1149 VGND.n26 585
R1207 VGND.n1150 VGND.n25 585
R1208 VGND.n454 VGND.n216 531.217
R1209 VGND.n465 VGND.n216 522.751
R1210 VGND.n1726 VGND.n306 514.894
R1211 VGND.n1287 VGND.t10 490.079
R1212 VGND.n422 VGND.t29 474.312
R1213 VGND.n1726 VGND.n1725 459.26
R1214 VGND.n1 VGND.t29 149.661
R1215 VGND.n1858 VGND.n216 448.981
R1216 VGND.n2046 VGND.n73 445.986
R1217 VGND.t11 VGND.t22 444.952
R1218 VGND.n2034 VGND.t29 442.993
R1219 VGND.n1654 VGND.t29 433.945
R1220 VGND.n1750 VGND.t29 425.445
R1221 VGND.n1075 VGND.n703 425.445
R1222 VGND.n1090 VGND.n1089 416
R1223 VGND.n798 VGND.n735 409.971
R1224 VGND.n1478 VGND.n1476 409.971
R1225 VGND.n2032 VGND.n73 369.911
R1226 VGND.n1119 VGND.n1118 368.283
R1227 VGND.n1040 VGND.t31 361.087
R1228 VGND.n1118 VGND.n1117 358.697
R1229 VGND.n1044 VGND.t31 358.697
R1230 VGND.t8 VGND.t11 352.743
R1231 VGND.n1113 VGND.t5 330
R1232 VGND.n1558 VGND.t29 327.661
R1233 VGND.t24 VGND.t8 326.132
R1234 VGND.n1741 VGND.t29 324.683
R1235 VGND.n1084 VGND.t31 324.683
R1236 VGND.t29 VGND.n306 323.404
R1237 VGND.n2 VGND.n193 214.464
R1238 VGND.n1491 VGND.t36 318.572
R1239 VGND.n1291 VGND.n1290 303.442
R1240 VGND VGND.n1542 292.5
R1241 VGND.n1542 VGND.t0 292.5
R1242 VGND.n1072 VGND.n703 289.349
R1243 VGND.n1974 VGND.n1973 284.928
R1244 VGND.n1708 VGND.n399 284.928
R1245 VGND.n540 VGND.n188 284.887
R1246 VGND.n2023 VGND.t36 282.301
R1247 VGND.n1974 VGND.n1921 281.55
R1248 VGND.n1708 VGND.n322 281.55
R1249 VGND.n1132 VGND.t31 281.058
R1250 VGND.n698 VGND.n693 279.906
R1251 VGND.n804 VGND.t31 263.303
R1252 VGND.n907 VGND.t7 262.935
R1253 VGND.n1972 VGND.n146 258.334
R1254 VGND.n1535 VGND.n1534 258.334
R1255 VGND.n398 VGND.n397 258.334
R1256 VGND.n1219 VGND.n1218 258.334
R1257 VGND.n1760 VGND.n1759 258.334
R1258 VGND.n1676 VGND.n1675 258.334
R1259 VGND.n568 VGND.n567 258.334
R1260 VGND.n1462 VGND.n1461 258.334
R1261 VGND.n1159 VGND.n1158 258.334
R1262 VGND.n1828 VGND.n232 257.466
R1263 VGND.n1573 VGND.n215 257.466
R1264 VGND.n453 VGND.n312 257.466
R1265 VGND.n626 VGND.n625 257.466
R1266 VGND.n1152 VGND.n1148 257.466
R1267 VGND.n1259 VGND.n736 257.466
R1268 VGND.n1475 VGND.n688 257.466
R1269 VGND.n1494 VGND.n1492 257.466
R1270 VGND.n983 VGND.n982 254.34
R1271 VGND.n983 VGND.n979 254.34
R1272 VGND.n983 VGND.n978 254.34
R1273 VGND.n983 VGND.n977 254.34
R1274 VGND.n983 VGND.n976 254.34
R1275 VGND.n282 VGND.n34 254.34
R1276 VGND.n268 VGND.n34 254.34
R1277 VGND.n273 VGND.n34 254.34
R1278 VGND.n237 VGND.n34 254.34
R1279 VGND.n1827 VGND.n34 254.34
R1280 VGND.n290 VGND.n28 254.34
R1281 VGND.n266 VGND.n28 254.34
R1282 VGND.n271 VGND.n28 254.34
R1283 VGND.n1818 VGND.n28 254.34
R1284 VGND.n240 VGND.n28 254.34
R1285 VGND.n1876 VGND.n1875 254.34
R1286 VGND.n1876 VGND.n199 254.34
R1287 VGND.n1876 VGND.n198 254.34
R1288 VGND.n1876 VGND.n197 254.34
R1289 VGND.n1853 VGND.n194 254.34
R1290 VGND.n1851 VGND.n194 254.34
R1291 VGND.n1841 VGND.n194 254.34
R1292 VGND.n1839 VGND.n194 254.34
R1293 VGND.n226 VGND.n194 254.34
R1294 VGND.n1858 VGND.n218 254.34
R1295 VGND.n1858 VGND.n219 254.34
R1296 VGND.n1858 VGND.n220 254.34
R1297 VGND.n1858 VGND.n221 254.34
R1298 VGND.n1858 VGND.n1857 254.34
R1299 VGND.n1859 VGND.n1858 254.34
R1300 VGND.n59 VGND.n28 254.34
R1301 VGND.n984 VGND.n983 254.34
R1302 VGND.n962 VGND.n58 254.34
R1303 VGND.n1004 VGND.n963 254.34
R1304 VGND.n1004 VGND.n964 254.34
R1305 VGND.n1004 VGND.n965 254.34
R1306 VGND.n1004 VGND.n966 254.34
R1307 VGND.n1004 VGND.n1003 254.34
R1308 VGND.n2063 VGND.n34 254.34
R1309 VGND.n1258 VGND.n740 254.34
R1310 VGND.n1258 VGND.n741 254.34
R1311 VGND.n1258 VGND.n742 254.34
R1312 VGND.n1258 VGND.n743 254.34
R1313 VGND.n1258 VGND.n1257 254.34
R1314 VGND.n875 VGND.n805 254.34
R1315 VGND.n1227 VGND.n805 254.34
R1316 VGND.n817 VGND.n805 254.34
R1317 VGND.n1241 VGND.n805 254.34
R1318 VGND.n1244 VGND.n805 254.34
R1319 VGND.n805 VGND.n803 254.34
R1320 VGND.n1453 VGND.n1339 254.34
R1321 VGND.n1453 VGND.n1340 254.34
R1322 VGND.n1453 VGND.n1341 254.34
R1323 VGND.n1453 VGND.n1342 254.34
R1324 VGND.n1453 VGND.n1452 254.34
R1325 VGND.n1469 VGND.n1468 254.34
R1326 VGND.n1469 VGND.n1329 254.34
R1327 VGND.n1469 VGND.n1328 254.34
R1328 VGND.n1469 VGND.n1327 254.34
R1329 VGND.n1469 VGND.n1326 254.34
R1330 VGND.n1277 VGND.n726 254.34
R1331 VGND.n1277 VGND.n727 254.34
R1332 VGND.n929 VGND.n34 254.34
R1333 VGND.n1704 VGND.n306 254.34
R1334 VGND.n1702 VGND.n306 254.34
R1335 VGND.n1696 VGND.n306 254.34
R1336 VGND.n403 VGND.n306 254.34
R1337 VGND.n1690 VGND.n306 254.34
R1338 VGND.n1558 VGND.n446 254.34
R1339 VGND.n1544 VGND.n308 254.34
R1340 VGND.n1545 VGND.n1544 254.34
R1341 VGND.n1552 VGND.n1544 254.34
R1342 VGND.n1544 VGND.n462 254.34
R1343 VGND.n1544 VGND.n451 254.34
R1344 VGND.n1544 VGND.n450 254.34
R1345 VGND.n1558 VGND.n1557 254.34
R1346 VGND.n1558 VGND.n444 254.34
R1347 VGND.n1559 VGND.n1558 254.34
R1348 VGND.n1558 VGND.n445 254.34
R1349 VGND.n1863 VGND.n194 254.34
R1350 VGND.n1876 VGND.n196 254.34
R1351 VGND.n1869 VGND.n207 254.34
R1352 VGND.n207 VGND.n204 254.34
R1353 VGND.n632 VGND.n207 254.34
R1354 VGND.n649 VGND.n207 254.34
R1355 VGND.n659 VGND.n207 254.34
R1356 VGND.n662 VGND.n207 254.34
R1357 VGND.n168 VGND.n141 254.34
R1358 VGND.n168 VGND.n143 254.34
R1359 VGND.n1982 VGND.n168 254.34
R1360 VGND.n1918 VGND.n168 254.34
R1361 VGND.n1992 VGND.n168 254.34
R1362 VGND.n1493 VGND.n168 254.34
R1363 VGND.n2039 VGND.n69 254.34
R1364 VGND.n1454 VGND.n1453 254.34
R1365 VGND.n2046 VGND.n74 254.34
R1366 VGND.n1876 VGND.n195 254.34
R1367 VGND.n107 VGND.n69 254.34
R1368 VGND.n83 VGND.n69 254.34
R1369 VGND.n95 VGND.n69 254.34
R1370 VGND.n86 VGND.n69 254.34
R1371 VGND.n2053 VGND.n69 254.34
R1372 VGND.n2048 VGND.n2046 254.34
R1373 VGND.n2046 VGND.n76 254.34
R1374 VGND.n2046 VGND.n77 254.34
R1375 VGND.n2046 VGND.n78 254.34
R1376 VGND.n2046 VGND.n2045 254.34
R1377 VGND.n1154 VGND.n28 254.34
R1378 VGND.n1151 VGND.n34 254.34
R1379 VGND.n2069 VGND.n28 254.34
R1380 VGND.n2072 VGND.n28 254.34
R1381 VGND.n40 VGND.n28 254.34
R1382 VGND.n2084 VGND.n28 254.34
R1383 VGND.n53 VGND.n34 254.34
R1384 VGND.n47 VGND.n34 254.34
R1385 VGND.n2078 VGND.n34 254.34
R1386 VGND.n34 VGND.n32 254.34
R1387 VGND.n932 VGND.n931 251.614
R1388 VGND.n1728 VGND.n304 251.614
R1389 VGND.n1724 VGND.n1723 251.614
R1390 VGND.n1865 VGND.n1864 251.614
R1391 VGND.n2062 VGND.n56 251.614
R1392 VGND.n1146 VGND.n739 251.614
R1393 VGND.n2038 VGND.n109 251.614
R1394 VGND.n2007 VGND.n2006 251.614
R1395 VGND.n313 VGND.n193 243.875
R1396 VGND.n1710 VGND.n193 243.875
R1397 VGND.n1717 VGND.n193 243.875
R1398 VGND.n439 VGND.n193 243.875
R1399 VGND.n1565 VGND.n193 243.875
R1400 VGND.n1568 VGND.n193 243.875
R1401 VGND.n432 VGND.t29 242.202
R1402 VGND.n1117 VGND.n896 241.523
R1403 VGND.n1045 VGND.n1044 241.523
R1404 VGND.n1721 VGND.n1720 234.058
R1405 VGND.n1569 VGND.n437 233.29
R1406 VGND.n1567 VGND.n1566 233.29
R1407 VGND.n1564 VGND.n440 233.29
R1408 VGND.n1716 VGND.n317 233.29
R1409 VGND.n1712 VGND.n1711 233.29
R1410 VGND.n1858 VGND.t29 230.476
R1411 VGND.n1113 VGND.n1112 229.565
R1412 VGND.n1072 VGND.n1071 229.565
R1413 VGND.t36 VGND.n69 227.483
R1414 VGND.n1 VGND.n194 1.99647
R1415 VGND.t29 VGND.n75 224.49
R1416 VGND.n1908 VGND.n172 223.268
R1417 VGND.n1885 VGND.n172 223.268
R1418 VGND.n1885 VGND.n185 223.268
R1419 VGND.n1895 VGND.n185 223.268
R1420 VGND.n1895 VGND.n186 223.268
R1421 VGND.n1878 VGND.n186 223.268
R1422 VGND VGND.t12 219.8
R1423 VGND VGND.t23 219.8
R1424 VGND.n1258 VGND.t31 216.657
R1425 VGND.n1453 VGND.t36 216.657
R1426 VGND.n983 VGND.t31 216.516
R1427 VGND.n916 VGND.n906 215.218
R1428 VGND.n1093 VGND.n906 215.218
R1429 VGND.n1094 VGND.n1093 215.218
R1430 VGND.n1096 VGND.n1094 215.218
R1431 VGND.n1096 VGND.n1095 215.218
R1432 VGND.n1104 VGND.n1103 215.218
R1433 VGND.n1104 VGND.n899 215.218
R1434 VGND.n1111 VGND.n899 215.218
R1435 VGND.n1112 VGND.n1111 215.218
R1436 VGND.n1013 VGND.n896 215.218
R1437 VGND.n1020 VGND.n1013 215.218
R1438 VGND.n1021 VGND.n1020 215.218
R1439 VGND.n1023 VGND.n1021 215.218
R1440 VGND.n1030 VGND.n1029 215.218
R1441 VGND.n1031 VGND.n1030 215.218
R1442 VGND.n1031 VGND.n1006 215.218
R1443 VGND.n1038 VGND.n1006 215.218
R1444 VGND.n1039 VGND.n1038 215.218
R1445 VGND.n1045 VGND.n955 215.218
R1446 VGND.n1051 VGND.n955 215.218
R1447 VGND.n1054 VGND.n1052 215.218
R1448 VGND.n1054 VGND.n1053 215.218
R1449 VGND.n1061 VGND.n1060 215.218
R1450 VGND.n1063 VGND.n1061 215.218
R1451 VGND.n1063 VGND.n1062 215.218
R1452 VGND.n1071 VGND.n1070 215.218
R1453 VGND.n1004 VGND.t31 215.129
R1454 VGND.n168 VGND.t36 213.635
R1455 VGND.t29 VGND.n1876 213.57
R1456 VGND.t10 VGND.t24 207.315
R1457 VGND.t31 VGND.n28 206.107
R1458 VGND VGND.t9 202.4
R1459 VGND.n1046 VGND.n958 195.049
R1460 VGND.n1831 VGND.n1830 195.049
R1461 VGND.n434 VGND.n433 195.049
R1462 VGND.n1155 VGND.n65 195.049
R1463 VGND.n1015 VGND.n895 195.049
R1464 VGND.n917 VGND.n915 195.049
R1465 VGND.n802 VGND.n769 195.049
R1466 VGND.n1470 VGND.n685 195.049
R1467 VGND.n663 VGND.n118 195.049
R1468 VGND.n1298 VGND.n698 194.192
R1469 VGND.n1528 VGND.n1527 190.476
R1470 VGND.n1528 VGND.n464 190.476
R1471 VGND.n1541 VGND.n465 190.476
R1472 VGND.n455 VGND.n454 190.476
R1473 VGND.n458 VGND.n455 190.476
R1474 VGND.n459 VGND.n458 190.476
R1475 VGND.n460 VGND.n459 190.476
R1476 VGND.n460 VGND.n447 190.476
R1477 VGND.n1554 VGND.n448 190.476
R1478 VGND.n1549 VGND.n448 190.476
R1479 VGND.n1549 VGND.n1548 190.476
R1480 VGND.n1548 VGND.n307 190.476
R1481 VGND.n1725 VGND.n307 190.476
R1482 VGND.n1073 VGND.n947 187.249
R1483 VGND.n1755 VGND.n63 187.249
R1484 VGND.n1685 VGND.n1684 187.249
R1485 VGND.n2059 VGND.n60 187.249
R1486 VGND.n1041 VGND.n960 187.249
R1487 VGND.n1114 VGND.n898 187.249
R1488 VGND.n876 VGND.n68 187.249
R1489 VGND.n2035 VGND.n114 187.249
R1490 VGND.n1937 VGND.n1936 185
R1491 VGND.n1935 VGND.n1934 185
R1492 VGND.n1933 VGND.n1932 185
R1493 VGND.n1931 VGND.n1930 185
R1494 VGND.n1929 VGND.n1928 185
R1495 VGND.n1927 VGND.n1926 185
R1496 VGND.n1925 VGND.n1924 185
R1497 VGND.n1923 VGND.n1922 185
R1498 VGND.n1921 VGND.n163 185
R1499 VGND.n1955 VGND.n1954 185
R1500 VGND.n1953 VGND.n1952 185
R1501 VGND.n1951 VGND.n1950 185
R1502 VGND.n1949 VGND.n1948 185
R1503 VGND.n1947 VGND.n1946 185
R1504 VGND.n1945 VGND.n1944 185
R1505 VGND.n1943 VGND.n1942 185
R1506 VGND.n1941 VGND.n1940 185
R1507 VGND.n1939 VGND.n1938 185
R1508 VGND.n1973 VGND.n1972 185
R1509 VGND.n1971 VGND.n1970 185
R1510 VGND.n1969 VGND.n1968 185
R1511 VGND.n1967 VGND.n1966 185
R1512 VGND.n1965 VGND.n1964 185
R1513 VGND.n1963 VGND.n1962 185
R1514 VGND.n1961 VGND.n1960 185
R1515 VGND.n1959 VGND.n1958 185
R1516 VGND.n1957 VGND.n1956 185
R1517 VGND.n381 VGND.n346 185
R1518 VGND.n395 VGND.n394 185
R1519 VGND.n393 VGND.n347 185
R1520 VGND.n392 VGND.n391 185
R1521 VGND.n390 VGND.n389 185
R1522 VGND.n388 VGND.n387 185
R1523 VGND.n386 VGND.n385 185
R1524 VGND.n384 VGND.n383 185
R1525 VGND.n382 VGND.n322 185
R1526 VGND.n364 VGND.n363 185
R1527 VGND.n366 VGND.n365 185
R1528 VGND.n368 VGND.n367 185
R1529 VGND.n370 VGND.n369 185
R1530 VGND.n372 VGND.n371 185
R1531 VGND.n374 VGND.n373 185
R1532 VGND.n376 VGND.n375 185
R1533 VGND.n378 VGND.n377 185
R1534 VGND.n380 VGND.n379 185
R1535 VGND.n399 VGND.n398 185
R1536 VGND.n348 VGND.n323 185
R1537 VGND.n350 VGND.n349 185
R1538 VGND.n352 VGND.n351 185
R1539 VGND.n354 VGND.n353 185
R1540 VGND.n356 VGND.n355 185
R1541 VGND.n358 VGND.n357 185
R1542 VGND.n360 VGND.n359 185
R1543 VGND.n362 VGND.n361 185
R1544 VGND.n838 VGND.n837 185
R1545 VGND.n836 VGND.n835 185
R1546 VGND.n834 VGND.n833 185
R1547 VGND.n832 VGND.n831 185
R1548 VGND.n830 VGND.n829 185
R1549 VGND.n828 VGND.n827 185
R1550 VGND.n826 VGND.n825 185
R1551 VGND.n766 VGND.n765 185
R1552 VGND.n1250 VGND.n1249 185
R1553 VGND.n856 VGND.n855 185
R1554 VGND.n854 VGND.n853 185
R1555 VGND.n852 VGND.n851 185
R1556 VGND.n850 VGND.n849 185
R1557 VGND.n848 VGND.n847 185
R1558 VGND.n846 VGND.n845 185
R1559 VGND.n844 VGND.n843 185
R1560 VGND.n842 VGND.n841 185
R1561 VGND.n840 VGND.n839 185
R1562 VGND.n1218 VGND.n1217 185
R1563 VGND.n872 VGND.n871 185
R1564 VGND.n870 VGND.n869 185
R1565 VGND.n868 VGND.n867 185
R1566 VGND.n866 VGND.n865 185
R1567 VGND.n864 VGND.n863 185
R1568 VGND.n862 VGND.n861 185
R1569 VGND.n860 VGND.n859 185
R1570 VGND.n858 VGND.n857 185
R1571 VGND.n1220 VGND.n1219 185
R1572 VGND.n823 VGND.n822 185
R1573 VGND.n821 VGND.n820 185
R1574 VGND.n1232 VGND.n1231 185
R1575 VGND.n1234 VGND.n1233 185
R1576 VGND.n811 VGND.n810 185
R1577 VGND.n807 VGND.n748 185
R1578 VGND.n1254 VGND.n1253 185
R1579 VGND.n767 VGND.n747 185
R1580 VGND.n1796 VGND.n261 185
R1581 VGND.n1811 VGND.n1810 185
R1582 VGND.n1809 VGND.n262 185
R1583 VGND.n1808 VGND.n1807 185
R1584 VGND.n1806 VGND.n1805 185
R1585 VGND.n1804 VGND.n1803 185
R1586 VGND.n1802 VGND.n1801 185
R1587 VGND.n1800 VGND.n1799 185
R1588 VGND.n1798 VGND.n1797 185
R1589 VGND.n1779 VGND.n1778 185
R1590 VGND.n1781 VGND.n1780 185
R1591 VGND.n1783 VGND.n1782 185
R1592 VGND.n1785 VGND.n1784 185
R1593 VGND.n1787 VGND.n1786 185
R1594 VGND.n1789 VGND.n1788 185
R1595 VGND.n1791 VGND.n1790 185
R1596 VGND.n1793 VGND.n1792 185
R1597 VGND.n1795 VGND.n1794 185
R1598 VGND.n1761 VGND.n1760 185
R1599 VGND.n1763 VGND.n1762 185
R1600 VGND.n1765 VGND.n1764 185
R1601 VGND.n1767 VGND.n1766 185
R1602 VGND.n1769 VGND.n1768 185
R1603 VGND.n1771 VGND.n1770 185
R1604 VGND.n1773 VGND.n1772 185
R1605 VGND.n1775 VGND.n1774 185
R1606 VGND.n1777 VGND.n1776 185
R1607 VGND.n1759 VGND.n1758 185
R1608 VGND.n286 VGND.n285 185
R1609 VGND.n284 VGND.n267 185
R1610 VGND.n270 VGND.n269 185
R1611 VGND.n272 VGND.n246 185
R1612 VGND.n1815 VGND.n1814 185
R1613 VGND.n245 VGND.n239 185
R1614 VGND.n1822 VGND.n1821 185
R1615 VGND.n1824 VGND.n1823 185
R1616 VGND.n1622 VGND.n1621 185
R1617 VGND.n1624 VGND.n1579 185
R1618 VGND.n1627 VGND.n1626 185
R1619 VGND.n1628 VGND.n1578 185
R1620 VGND.n1630 VGND.n1629 185
R1621 VGND.n1632 VGND.n1577 185
R1622 VGND.n1635 VGND.n1634 185
R1623 VGND.n1636 VGND.n1576 185
R1624 VGND.n1638 VGND.n1637 185
R1625 VGND.n1604 VGND.n1584 185
R1626 VGND.n1606 VGND.n1605 185
R1627 VGND.n1608 VGND.n1607 185
R1628 VGND.n1611 VGND.n1610 185
R1629 VGND.n1612 VGND.n1582 185
R1630 VGND.n1614 VGND.n1613 185
R1631 VGND.n1616 VGND.n1581 185
R1632 VGND.n1619 VGND.n1618 185
R1633 VGND.n1620 VGND.n1580 185
R1634 VGND.n1677 VGND.n1676 185
R1635 VGND.n1590 VGND.n411 185
R1636 VGND.n1592 VGND.n1591 185
R1637 VGND.n1593 VGND.n1588 185
R1638 VGND.n1595 VGND.n1594 185
R1639 VGND.n1597 VGND.n1586 185
R1640 VGND.n1599 VGND.n1598 185
R1641 VGND.n1600 VGND.n1585 185
R1642 VGND.n1602 VGND.n1601 185
R1643 VGND.n1675 VGND.n410 185
R1644 VGND.n1673 VGND.n1672 185
R1645 VGND.n1664 VGND.n413 185
R1646 VGND.n1663 VGND.n1662 185
R1647 VGND.n1660 VGND.n418 185
R1648 VGND.n1658 VGND.n1657 185
R1649 VGND.n429 VGND.n419 185
R1650 VGND.n1641 VGND.n428 185
R1651 VGND.n1643 VGND.n1642 185
R1652 VGND.n605 VGND.n604 185
R1653 VGND.n607 VGND.n606 185
R1654 VGND.n609 VGND.n608 185
R1655 VGND.n611 VGND.n610 185
R1656 VGND.n613 VGND.n612 185
R1657 VGND.n615 VGND.n614 185
R1658 VGND.n617 VGND.n616 185
R1659 VGND.n619 VGND.n618 185
R1660 VGND.n620 VGND.n562 185
R1661 VGND.n587 VGND.n586 185
R1662 VGND.n589 VGND.n588 185
R1663 VGND.n591 VGND.n590 185
R1664 VGND.n593 VGND.n592 185
R1665 VGND.n595 VGND.n594 185
R1666 VGND.n597 VGND.n596 185
R1667 VGND.n599 VGND.n598 185
R1668 VGND.n601 VGND.n600 185
R1669 VGND.n603 VGND.n602 185
R1670 VGND.n569 VGND.n568 185
R1671 VGND.n571 VGND.n570 185
R1672 VGND.n573 VGND.n572 185
R1673 VGND.n575 VGND.n574 185
R1674 VGND.n577 VGND.n576 185
R1675 VGND.n579 VGND.n578 185
R1676 VGND.n581 VGND.n580 185
R1677 VGND.n583 VGND.n582 185
R1678 VGND.n585 VGND.n584 185
R1679 VGND.n567 VGND.n203 185
R1680 VGND.n629 VGND.n202 185
R1681 VGND.n631 VGND.n630 185
R1682 VGND.n641 VGND.n640 185
R1683 VGND.n646 VGND.n545 185
R1684 VGND.n675 VGND.n674 185
R1685 VGND.n656 VGND.n544 185
R1686 VGND.n651 VGND.n563 185
R1687 VGND.n671 VGND.n670 185
R1688 VGND.n1391 VGND.n1390 185
R1689 VGND.n1393 VGND.n1348 185
R1690 VGND.n1396 VGND.n1395 185
R1691 VGND.n1397 VGND.n1347 185
R1692 VGND.n1399 VGND.n1398 185
R1693 VGND.n1401 VGND.n1346 185
R1694 VGND.n1404 VGND.n1403 185
R1695 VGND.n1405 VGND.n1345 185
R1696 VGND.n1407 VGND.n1406 185
R1697 VGND.n1373 VGND.n1353 185
R1698 VGND.n1375 VGND.n1374 185
R1699 VGND.n1377 VGND.n1376 185
R1700 VGND.n1380 VGND.n1379 185
R1701 VGND.n1381 VGND.n1351 185
R1702 VGND.n1383 VGND.n1382 185
R1703 VGND.n1385 VGND.n1350 185
R1704 VGND.n1388 VGND.n1387 185
R1705 VGND.n1389 VGND.n1349 185
R1706 VGND.n1463 VGND.n1462 185
R1707 VGND.n1359 VGND.n1332 185
R1708 VGND.n1361 VGND.n1360 185
R1709 VGND.n1362 VGND.n1357 185
R1710 VGND.n1364 VGND.n1363 185
R1711 VGND.n1366 VGND.n1355 185
R1712 VGND.n1368 VGND.n1367 185
R1713 VGND.n1369 VGND.n1354 185
R1714 VGND.n1371 VGND.n1370 185
R1715 VGND.n1461 VGND.n1334 185
R1716 VGND.n1459 VGND.n1458 185
R1717 VGND.n1425 VGND.n1335 185
R1718 VGND.n1431 VGND.n1430 185
R1719 VGND.n1436 VGND.n1435 185
R1720 VGND.n1433 VGND.n1415 185
R1721 VGND.n1432 VGND.n1414 185
R1722 VGND.n1446 VGND.n1445 185
R1723 VGND.n1448 VGND.n1447 185
R1724 VGND.n397 VGND.t37 185
R1725 VGND.t37 VGND.n326 185
R1726 VGND.n341 VGND.n310 185
R1727 VGND.n1532 VGND.n1531 185
R1728 VGND.n1522 VGND.n484 185
R1729 VGND.t38 VGND.n484 185
R1730 VGND.n1521 VGND.n1520 185
R1731 VGND.n1518 VGND.n1517 185
R1732 VGND.n1516 VGND.n181 185
R1733 VGND.n1901 VGND.n1900 185
R1734 VGND.n1903 VGND.n1902 185
R1735 VGND.n504 VGND.n503 185
R1736 VGND.n502 VGND.n501 185
R1737 VGND.n500 VGND.n499 185
R1738 VGND.n498 VGND.n497 185
R1739 VGND.n496 VGND.n495 185
R1740 VGND.n494 VGND.n493 185
R1741 VGND.n492 VGND.n491 185
R1742 VGND.n490 VGND.n489 185
R1743 VGND.n488 VGND.n487 185
R1744 VGND.n532 VGND.n531 185
R1745 VGND.n533 VGND.n485 185
R1746 VGND.n535 VGND.n534 185
R1747 VGND.n515 VGND.n486 185
R1748 VGND.n514 VGND.n513 185
R1749 VGND.n512 VGND.n511 185
R1750 VGND.n510 VGND.n509 185
R1751 VGND.n508 VGND.n507 185
R1752 VGND.n506 VGND.n505 185
R1753 VGND.n1536 VGND.n1535 185
R1754 VGND.n516 VGND.n469 185
R1755 VGND.n518 VGND.n517 185
R1756 VGND.n520 VGND.n519 185
R1757 VGND.n522 VGND.n521 185
R1758 VGND.n524 VGND.n523 185
R1759 VGND.n526 VGND.n525 185
R1760 VGND.n528 VGND.n527 185
R1761 VGND.n530 VGND.n529 185
R1762 VGND.n1534 VGND.n468 185
R1763 VGND.n1534 VGND.t38 185
R1764 VGND.n539 VGND.n471 185
R1765 VGND.n146 VGND.n142 185
R1766 VGND.n2000 VGND.n1999 185
R1767 VGND.n1979 VGND.n145 185
R1768 VGND.n1978 VGND.n1977 185
R1769 VGND.n1976 VGND.n1975 185
R1770 VGND.n1987 VGND.n1986 185
R1771 VGND.n1989 VGND.n1988 185
R1772 VGND.n166 VGND.n164 185
R1773 VGND.n1996 VGND.n1995 185
R1774 VGND.n1196 VGND.n1195 185
R1775 VGND.n1198 VGND.n1197 185
R1776 VGND.n1200 VGND.n1199 185
R1777 VGND.n1202 VGND.n1201 185
R1778 VGND.n1204 VGND.n1203 185
R1779 VGND.n1206 VGND.n1205 185
R1780 VGND.n1208 VGND.n1207 185
R1781 VGND.n1210 VGND.n1209 185
R1782 VGND.n1211 VGND.n23 185
R1783 VGND.n1178 VGND.n1177 185
R1784 VGND.n1180 VGND.n1179 185
R1785 VGND.n1182 VGND.n1181 185
R1786 VGND.n1184 VGND.n1183 185
R1787 VGND.n1186 VGND.n1185 185
R1788 VGND.n1188 VGND.n1187 185
R1789 VGND.n1190 VGND.n1189 185
R1790 VGND.n1192 VGND.n1191 185
R1791 VGND.n1194 VGND.n1193 185
R1792 VGND.n1160 VGND.n1159 185
R1793 VGND.n1162 VGND.n1161 185
R1794 VGND.n1164 VGND.n1163 185
R1795 VGND.n1166 VGND.n1165 185
R1796 VGND.n1168 VGND.n1167 185
R1797 VGND.n1170 VGND.n1169 185
R1798 VGND.n1172 VGND.n1171 185
R1799 VGND.n1174 VGND.n1173 185
R1800 VGND.n1176 VGND.n1175 185
R1801 VGND.n1158 VGND.n46 185
R1802 VGND.n45 VGND.n44 185
R1803 VGND.n48 VGND.n6 185
R1804 VGND.n2092 VGND.n2091 185
R1805 VGND.n2075 VGND.n5 185
R1806 VGND.n38 VGND.n37 185
R1807 VGND.n36 VGND.n31 185
R1808 VGND.n30 VGND.n24 185
R1809 VGND.n2088 VGND.n2087 185
R1810 VGND.n175 VGND.n140 184.113
R1811 VGND.t0 VGND.n464 182.012
R1812 VGND.n1527 VGND.t13 177.779
R1813 VGND.n980 VGND.n969 175.546
R1814 VGND.n971 VGND.n970 175.546
R1815 VGND.n973 VGND.n972 175.546
R1816 VGND.n975 VGND.n974 175.546
R1817 VGND.n986 VGND.n985 175.546
R1818 VGND.n1046 VGND.n956 175.546
R1819 VGND.n1050 VGND.n956 175.546
R1820 VGND.n1050 VGND.n954 175.546
R1821 VGND.n1055 VGND.n954 175.546
R1822 VGND.n1055 VGND.n952 175.546
R1823 VGND.n1059 VGND.n952 175.546
R1824 VGND.n1059 VGND.n951 175.546
R1825 VGND.n1064 VGND.n951 175.546
R1826 VGND.n1064 VGND.n949 175.546
R1827 VGND.n1069 VGND.n949 175.546
R1828 VGND.n1069 VGND.n947 175.546
R1829 VGND.n1077 VGND.n1074 175.546
R1830 VGND.n1077 VGND.n945 175.546
R1831 VGND.n1081 VGND.n945 175.546
R1832 VGND.n1081 VGND.n923 175.546
R1833 VGND.n1085 VGND.n923 175.546
R1834 VGND.n1085 VGND.n943 175.546
R1835 VGND.n943 VGND.n924 175.546
R1836 VGND.n939 VGND.n924 175.546
R1837 VGND.n939 VGND.n926 175.546
R1838 VGND.n935 VGND.n926 175.546
R1839 VGND.n935 VGND.n932 175.546
R1840 VGND.n1826 VGND.n233 175.546
R1841 VGND.n243 VGND.n238 175.546
R1842 VGND.n275 VGND.n274 175.546
R1843 VGND.n283 VGND.n280 175.546
R1844 VGND.n281 VGND.n265 175.546
R1845 VGND.n1836 VGND.n1835 175.546
R1846 VGND.n1844 VGND.n1843 175.546
R1847 VGND.n1848 VGND.n1847 175.546
R1848 VGND.n1856 VGND.n222 175.546
R1849 VGND.n1860 VGND.n214 175.546
R1850 VGND.n1830 VGND.n229 175.546
R1851 VGND.n1819 VGND.n241 175.546
R1852 VGND.n1817 VGND.n242 175.546
R1853 VGND.n278 VGND.n277 175.546
R1854 VGND.n289 VGND.n288 175.546
R1855 VGND.n1756 VGND.n1755 175.546
R1856 VGND.n1751 VGND.n293 175.546
R1857 VGND.n1747 VGND.n293 175.546
R1858 VGND.n1747 VGND.n295 175.546
R1859 VGND.n1743 VGND.n295 175.546
R1860 VGND.n1743 VGND.n1740 175.546
R1861 VGND.n1740 VGND.n297 175.546
R1862 VGND.n1736 VGND.n297 175.546
R1863 VGND.n1736 VGND.n299 175.546
R1864 VGND.n1732 VGND.n299 175.546
R1865 VGND.n1732 VGND.n302 175.546
R1866 VGND.n1728 VGND.n302 175.546
R1867 VGND.n1573 VGND.n430 175.546
R1868 VGND.n1648 VGND.n430 175.546
R1869 VGND.n1649 VGND.n1648 175.546
R1870 VGND.n1649 VGND.n425 175.546
R1871 VGND.n1655 VGND.n425 175.546
R1872 VGND.n1655 VGND.n417 175.546
R1873 VGND.n1666 VGND.n417 175.546
R1874 VGND.n1667 VGND.n1666 175.546
R1875 VGND.n1667 VGND.n409 175.546
R1876 VGND.n1681 VGND.n409 175.546
R1877 VGND.n1681 VGND.n304 175.546
R1878 VGND.n1689 VGND.n405 175.546
R1879 VGND.n1692 VGND.n1691 175.546
R1880 VGND.n1697 VGND.n1695 175.546
R1881 VGND.n1701 VGND.n401 175.546
R1882 VGND.n1705 VGND.n1703 175.546
R1883 VGND.n1723 VGND.n309 175.546
R1884 VGND.n457 VGND.n456 175.546
R1885 VGND.n461 VGND.n452 175.546
R1886 VGND.n1553 VGND.n449 175.546
R1887 VGND.n1551 VGND.n1550 175.546
R1888 VGND.n1547 VGND.n1546 175.546
R1889 VGND.n1556 VGND.n1555 175.546
R1890 VGND.n1555 VGND.n441 175.546
R1891 VGND.n1560 VGND.n442 175.546
R1892 VGND.n443 VGND.n318 175.546
R1893 VGND.n320 VGND.n319 175.546
R1894 VGND.n321 VGND.n320 175.546
R1895 VGND.n1645 VGND.n433 175.546
R1896 VGND.n1645 VGND.n427 175.546
R1897 VGND.n1651 VGND.n427 175.546
R1898 VGND.n1652 VGND.n1651 175.546
R1899 VGND.n1652 VGND.n424 175.546
R1900 VGND.n424 VGND.n423 175.546
R1901 VGND.n423 VGND.n415 175.546
R1902 VGND.n1669 VGND.n415 175.546
R1903 VGND.n1670 VGND.n1669 175.546
R1904 VGND.n1670 VGND.n407 175.546
R1905 VGND.n1684 VGND.n407 175.546
R1906 VGND.n2085 VGND.n27 175.546
R1907 VGND.n2083 VGND.n29 175.546
R1908 VGND.n2073 VGND.n41 175.546
R1909 VGND.n2071 VGND.n2070 175.546
R1910 VGND.n2068 VGND.n43 175.546
R1911 VGND.n2049 VGND.n72 175.546
R1912 VGND.n91 VGND.n90 175.546
R1913 VGND.n101 VGND.n100 175.546
R1914 VGND.n2044 VGND.n80 175.546
R1915 VGND.n111 VGND.n79 175.546
R1916 VGND.n668 VGND.n667 175.546
R1917 VGND.n654 VGND.n653 175.546
R1918 VGND.n644 VGND.n643 175.546
R1919 VGND.n638 VGND.n200 175.546
R1920 VGND.n1874 VGND.n201 175.546
R1921 VGND.n1838 VGND.n227 175.546
R1922 VGND.n1842 VGND.n1840 175.546
R1923 VGND.n1850 VGND.n224 175.546
R1924 VGND.n1854 VGND.n1852 175.546
R1925 VGND.n1862 VGND.n211 175.546
R1926 VGND.n1005 VGND.n961 175.546
R1927 VGND.n1002 VGND.n967 175.546
R1928 VGND.n998 VGND.n997 175.546
R1929 VGND.n994 VGND.n993 175.546
R1930 VGND.n990 VGND.n989 175.546
R1931 VGND.n1150 VGND.n1149 175.546
R1932 VGND.n2080 VGND.n2079 175.546
R1933 VGND.n2077 VGND.n35 175.546
R1934 VGND.n52 VGND.n50 175.546
R1935 VGND.n2065 VGND.n2064 175.546
R1936 VGND.n1121 VGND.n1120 175.546
R1937 VGND.n1121 VGND.n891 175.546
R1938 VGND.n1127 VGND.n891 175.546
R1939 VGND.n1127 VGND.n886 175.546
R1940 VGND.n1133 VGND.n886 175.546
R1941 VGND.n1135 VGND.n1133 175.546
R1942 VGND.n1136 VGND.n1135 175.546
R1943 VGND.n1136 VGND.n882 175.546
R1944 VGND.n1142 VGND.n882 175.546
R1945 VGND.n1142 VGND.n878 175.546
R1946 VGND.n1148 VGND.n878 175.546
R1947 VGND.n1015 VGND.n1014 175.546
R1948 VGND.n1019 VGND.n1014 175.546
R1949 VGND.n1019 VGND.n1012 175.546
R1950 VGND.n1024 VGND.n1012 175.546
R1951 VGND.n1024 VGND.n1010 175.546
R1952 VGND.n1028 VGND.n1010 175.546
R1953 VGND.n1028 VGND.n1009 175.546
R1954 VGND.n1032 VGND.n1009 175.546
R1955 VGND.n1032 VGND.n1007 175.546
R1956 VGND.n1037 VGND.n1007 175.546
R1957 VGND.n1037 VGND.n960 175.546
R1958 VGND.n911 VGND.n910 175.546
R1959 VGND.n1276 VGND.n728 175.546
R1960 VGND.n1276 VGND.n729 175.546
R1961 VGND.n1272 VGND.n729 175.546
R1962 VGND.n1272 VGND.n732 175.546
R1963 VGND.n1267 VGND.n732 175.546
R1964 VGND.n1267 VGND.n734 175.546
R1965 VGND.n1263 VGND.n734 175.546
R1966 VGND.n1263 VGND.n736 175.546
R1967 VGND.n918 VGND.n917 175.546
R1968 VGND.n1092 VGND.n918 175.546
R1969 VGND.n1092 VGND.n905 175.546
R1970 VGND.n1097 VGND.n905 175.546
R1971 VGND.n1097 VGND.n903 175.546
R1972 VGND.n1101 VGND.n903 175.546
R1973 VGND.n1101 VGND.n902 175.546
R1974 VGND.n1105 VGND.n902 175.546
R1975 VGND.n1105 VGND.n900 175.546
R1976 VGND.n1110 VGND.n900 175.546
R1977 VGND.n1110 VGND.n898 175.546
R1978 VGND.n1123 VGND.n893 175.546
R1979 VGND.n1124 VGND.n1123 175.546
R1980 VGND.n1124 VGND.n889 175.546
R1981 VGND.n1130 VGND.n889 175.546
R1982 VGND.n1131 VGND.n1130 175.546
R1983 VGND.n1131 VGND.n884 175.546
R1984 VGND.n1138 VGND.n884 175.546
R1985 VGND.n1139 VGND.n1138 175.546
R1986 VGND.n1139 VGND.n880 175.546
R1987 VGND.n1145 VGND.n880 175.546
R1988 VGND.n1146 VGND.n1145 175.546
R1989 VGND.n1259 VGND.n738 175.546
R1990 VGND.n1256 VGND.n744 175.546
R1991 VGND.n1237 VGND.n1236 175.546
R1992 VGND.n815 VGND.n814 175.546
R1993 VGND.n1223 VGND.n1222 175.546
R1994 VGND.n873 VGND.n739 175.546
R1995 VGND.n796 VGND.n795 175.546
R1996 VGND.n795 VGND.n772 175.546
R1997 VGND.n791 VGND.n772 175.546
R1998 VGND.n791 VGND.n778 175.546
R1999 VGND.n787 VGND.n778 175.546
R2000 VGND.n787 VGND.n781 175.546
R2001 VGND.n783 VGND.n781 175.546
R2002 VGND.n783 VGND.n690 175.546
R2003 VGND.n1321 VGND.n690 175.546
R2004 VGND.n1321 VGND.n687 175.546
R2005 VGND.n1475 VGND.n687 175.546
R2006 VGND.n1246 VGND.n1245 175.546
R2007 VGND.n1243 VGND.n1242 175.546
R2008 VGND.n1240 VGND.n809 175.546
R2009 VGND.n1229 VGND.n1228 175.546
R2010 VGND.n1226 VGND.n819 175.546
R2011 VGND.n2052 VGND.n70 175.546
R2012 VGND.n94 VGND.n87 175.546
R2013 VGND.n97 VGND.n96 175.546
R2014 VGND.n106 VGND.n105 175.546
R2015 VGND.n2041 VGND.n2040 175.546
R2016 VGND.n1451 VGND.n1343 175.546
R2017 VGND.n1443 VGND.n1442 175.546
R2018 VGND.n1418 VGND.n1417 175.546
R2019 VGND.n1428 VGND.n1427 175.546
R2020 VGND.n1456 VGND.n1455 175.546
R2021 VGND.n1470 VGND.n1325 175.546
R2022 VGND.n1412 VGND.n1411 175.546
R2023 VGND.n1439 VGND.n1438 175.546
R2024 VGND.n1423 VGND.n1422 175.546
R2025 VGND.n1336 VGND.n1330 175.546
R2026 VGND.n1467 VGND.n114 175.546
R2027 VGND.n2033 VGND.n115 175.546
R2028 VGND.n120 VGND.n115 175.546
R2029 VGND.n121 VGND.n120 175.546
R2030 VGND.n125 VGND.n121 175.546
R2031 VGND.n126 VGND.n125 175.546
R2032 VGND.n128 VGND.n126 175.546
R2033 VGND.n129 VGND.n128 175.546
R2034 VGND.n133 VGND.n129 175.546
R2035 VGND.n134 VGND.n133 175.546
R2036 VGND.n137 VGND.n134 175.546
R2037 VGND.n2007 VGND.n137 175.546
R2038 VGND.n1993 VGND.n167 175.546
R2039 VGND.n1991 VGND.n169 175.546
R2040 VGND.n1984 VGND.n1983 175.546
R2041 VGND.n1981 VGND.n1920 175.546
R2042 VGND.n2003 VGND.n2002 175.546
R2043 VGND.n1480 VGND.n683 175.546
R2044 VGND.n1484 VGND.n683 175.546
R2045 VGND.n1484 VGND.n680 175.546
R2046 VGND.n1510 VGND.n680 175.546
R2047 VGND.n1510 VGND.n681 175.546
R2048 VGND.n1506 VGND.n681 175.546
R2049 VGND.n1506 VGND.n1488 175.546
R2050 VGND.n1502 VGND.n1488 175.546
R2051 VGND.n1502 VGND.n1490 175.546
R2052 VGND.n1498 VGND.n1490 175.546
R2053 VGND.n1498 VGND.n1492 175.546
R2054 VGND.n661 VGND.n660 175.546
R2055 VGND.n658 VGND.n650 175.546
R2056 VGND.n648 VGND.n628 175.546
R2057 VGND.n636 VGND.n635 175.546
R2058 VGND.n1871 VGND.n1870 175.546
R2059 VGND.n2031 VGND.n2030 175.546
R2060 VGND.n2030 VGND.n119 175.546
R2061 VGND.n2026 VGND.n119 175.546
R2062 VGND.n2026 VGND.n123 175.546
R2063 VGND.n2022 VGND.n123 175.546
R2064 VGND.n2022 VGND.n127 175.546
R2065 VGND.n2018 VGND.n127 175.546
R2066 VGND.n2018 VGND.n131 175.546
R2067 VGND.n2014 VGND.n131 175.546
R2068 VGND.n2014 VGND.n136 175.546
R2069 VGND.n2009 VGND.n136 175.546
R2070 VGND.n1062 VGND.t1 167.392
R2071 VGND.n1905 VGND.n175 165.702
R2072 VGND.n1905 VGND.n176 165.702
R2073 VGND.n1898 VGND.n176 165.702
R2074 VGND.n1898 VGND.n182 165.702
R2075 VGND.n541 VGND.n182 165.702
R2076 VGND.n1524 VGND.n541 165.702
R2077 VGND.n1525 VGND.n1524 165.702
R2078 VGND.n1938 VGND.n1937 163.333
R2079 VGND.n505 VGND.n504 163.333
R2080 VGND.n379 VGND.n346 163.333
R2081 VGND.n839 VGND.n838 163.333
R2082 VGND.n1794 VGND.n261 163.333
R2083 VGND.n1622 VGND.n1580 163.333
R2084 VGND.n604 VGND.n603 163.333
R2085 VGND.n1391 VGND.n1349 163.333
R2086 VGND.n1195 VGND.n1194 163.333
R2087 VGND.n1719 VGND.n1718 158.119
R2088 VGND.n1529 VGND.n1525 158.012
R2089 VGND.n1316 VGND.n1315 155.239
R2090 VGND.n1103 VGND.t6 153.043
R2091 VGND.n963 VGND.n962 152.643
R2092 VGND.n1942 VGND.n1941 150
R2093 VGND.n1946 VGND.n1945 150
R2094 VGND.n1950 VGND.n1949 150
R2095 VGND.n1954 VGND.n1953 150
R2096 VGND.n1958 VGND.n1957 150
R2097 VGND.n1962 VGND.n1961 150
R2098 VGND.n1966 VGND.n1965 150
R2099 VGND.n1970 VGND.n1969 150
R2100 VGND.n1996 VGND.n164 150
R2101 VGND.n1988 VGND.n1987 150
R2102 VGND.n1977 VGND.n1976 150
R2103 VGND.n1999 VGND.n145 150
R2104 VGND.n1934 VGND.n1933 150
R2105 VGND.n1930 VGND.n1929 150
R2106 VGND.n1926 VGND.n1925 150
R2107 VGND.n1922 VGND.n163 150
R2108 VGND.n501 VGND.n500 150
R2109 VGND.n497 VGND.n496 150
R2110 VGND.n493 VGND.n492 150
R2111 VGND.n489 VGND.n488 150
R2112 VGND.n509 VGND.n508 150
R2113 VGND.n513 VGND.n512 150
R2114 VGND.n535 VGND.n486 150
R2115 VGND.n531 VGND.n485 150
R2116 VGND.n529 VGND.n528 150
R2117 VGND.n525 VGND.n524 150
R2118 VGND.n521 VGND.n520 150
R2119 VGND.n517 VGND.n516 150
R2120 VGND.n1902 VGND.n1901 150
R2121 VGND.n1517 VGND.n1516 150
R2122 VGND.n1520 VGND.n484 150
R2123 VGND.n1532 VGND.n484 150
R2124 VGND.n1534 VGND.n471 150
R2125 VGND.n395 VGND.n347 150
R2126 VGND.n391 VGND.n390 150
R2127 VGND.n387 VGND.n386 150
R2128 VGND.n383 VGND.n382 150
R2129 VGND.n377 VGND.n376 150
R2130 VGND.n373 VGND.n372 150
R2131 VGND.n369 VGND.n368 150
R2132 VGND.n365 VGND.n364 150
R2133 VGND.n361 VGND.n360 150
R2134 VGND.n357 VGND.n356 150
R2135 VGND.n353 VGND.n352 150
R2136 VGND.n349 VGND.n348 150
R2137 VGND.n341 VGND.n326 150
R2138 VGND.n843 VGND.n842 150
R2139 VGND.n847 VGND.n846 150
R2140 VGND.n851 VGND.n850 150
R2141 VGND.n855 VGND.n854 150
R2142 VGND.n859 VGND.n858 150
R2143 VGND.n863 VGND.n862 150
R2144 VGND.n867 VGND.n866 150
R2145 VGND.n871 VGND.n870 150
R2146 VGND.n1253 VGND.n747 150
R2147 VGND.n810 VGND.n748 150
R2148 VGND.n1233 VGND.n1232 150
R2149 VGND.n822 VGND.n821 150
R2150 VGND.n835 VGND.n834 150
R2151 VGND.n831 VGND.n830 150
R2152 VGND.n827 VGND.n826 150
R2153 VGND.n1250 VGND.n765 150
R2154 VGND.n1792 VGND.n1791 150
R2155 VGND.n1788 VGND.n1787 150
R2156 VGND.n1784 VGND.n1783 150
R2157 VGND.n1780 VGND.n1779 150
R2158 VGND.n1776 VGND.n1775 150
R2159 VGND.n1772 VGND.n1771 150
R2160 VGND.n1768 VGND.n1767 150
R2161 VGND.n1764 VGND.n1763 150
R2162 VGND.n1823 VGND.n1822 150
R2163 VGND.n1814 VGND.n245 150
R2164 VGND.n269 VGND.n246 150
R2165 VGND.n285 VGND.n284 150
R2166 VGND.n1811 VGND.n262 150
R2167 VGND.n1807 VGND.n1806 150
R2168 VGND.n1803 VGND.n1802 150
R2169 VGND.n1799 VGND.n1798 150
R2170 VGND.n1618 VGND.n1616 150
R2171 VGND.n1614 VGND.n1582 150
R2172 VGND.n1610 VGND.n1608 150
R2173 VGND.n1605 VGND.n1604 150
R2174 VGND.n1602 VGND.n1585 150
R2175 VGND.n1598 VGND.n1597 150
R2176 VGND.n1595 VGND.n1588 150
R2177 VGND.n1591 VGND.n1590 150
R2178 VGND.n1642 VGND.n1641 150
R2179 VGND.n1658 VGND.n419 150
R2180 VGND.n1662 VGND.n1660 150
R2181 VGND.n1673 VGND.n413 150
R2182 VGND.n1626 VGND.n1624 150
R2183 VGND.n1630 VGND.n1578 150
R2184 VGND.n1634 VGND.n1632 150
R2185 VGND.n1638 VGND.n1576 150
R2186 VGND.n600 VGND.n599 150
R2187 VGND.n596 VGND.n595 150
R2188 VGND.n592 VGND.n591 150
R2189 VGND.n588 VGND.n587 150
R2190 VGND.n584 VGND.n583 150
R2191 VGND.n580 VGND.n579 150
R2192 VGND.n576 VGND.n575 150
R2193 VGND.n572 VGND.n571 150
R2194 VGND.n671 VGND.n563 150
R2195 VGND.n674 VGND.n544 150
R2196 VGND.n640 VGND.n545 150
R2197 VGND.n630 VGND.n629 150
R2198 VGND.n608 VGND.n607 150
R2199 VGND.n612 VGND.n611 150
R2200 VGND.n616 VGND.n615 150
R2201 VGND.n618 VGND.n562 150
R2202 VGND.n1387 VGND.n1385 150
R2203 VGND.n1383 VGND.n1351 150
R2204 VGND.n1379 VGND.n1377 150
R2205 VGND.n1374 VGND.n1373 150
R2206 VGND.n1371 VGND.n1354 150
R2207 VGND.n1367 VGND.n1366 150
R2208 VGND.n1364 VGND.n1357 150
R2209 VGND.n1360 VGND.n1359 150
R2210 VGND.n1447 VGND.n1446 150
R2211 VGND.n1433 VGND.n1432 150
R2212 VGND.n1435 VGND.n1431 150
R2213 VGND.n1459 VGND.n1335 150
R2214 VGND.n1395 VGND.n1393 150
R2215 VGND.n1399 VGND.n1347 150
R2216 VGND.n1403 VGND.n1401 150
R2217 VGND.n1407 VGND.n1345 150
R2218 VGND.n1191 VGND.n1190 150
R2219 VGND.n1187 VGND.n1186 150
R2220 VGND.n1183 VGND.n1182 150
R2221 VGND.n1179 VGND.n1178 150
R2222 VGND.n1175 VGND.n1174 150
R2223 VGND.n1171 VGND.n1170 150
R2224 VGND.n1167 VGND.n1166 150
R2225 VGND.n1163 VGND.n1162 150
R2226 VGND.n2088 VGND.n24 150
R2227 VGND.n37 VGND.n36 150
R2228 VGND.n2091 VGND.n5 150
R2229 VGND.n44 VGND.n6 150
R2230 VGND.n1199 VGND.n1198 150
R2231 VGND.n1203 VGND.n1202 150
R2232 VGND.n1207 VGND.n1206 150
R2233 VGND.n1209 VGND.n23 150
R2234 VGND.n1289 VGND.n702 148.845
R2235 VGND.n715 VGND.n702 148.845
R2236 VGND.n716 VGND.n715 148.845
R2237 VGND.n716 VGND.n707 148.845
R2238 VGND.n1285 VGND.n707 148.845
R2239 VGND.n1285 VGND.n701 148.845
R2240 VGND.t3 VGND.n1039 148.262
R2241 VGND.n1884 VGND.n183 143.916
R2242 VGND.n1540 VGND.n466 141.84
R2243 VGND.n1540 VGND.n467 141.84
R2244 VGND.n1315 VGND.n693 139.446
R2245 VGND.t4 VGND.n1022 133.913
R2246 VGND.n804 VGND.t36 133.431
R2247 VGND.n908 VGND.n907 131.19
R2248 VGND.n1526 VGND.n466 129.232
R2249 VGND.n1883 VGND.n174 126.984
R2250 VGND.n1074 VGND.n1073 126.782
R2251 VGND.n1751 VGND.n63 126.782
R2252 VGND.n1685 VGND.n405 126.782
R2253 VGND.n2059 VGND.n61 126.782
R2254 VGND.n1041 VGND.n1005 126.782
R2255 VGND.n1114 VGND.n893 126.782
R2256 VGND.n2054 VGND.n68 126.782
R2257 VGND.n2035 VGND.n2033 126.782
R2258 VGND.n981 VGND.n958 124.832
R2259 VGND.n1832 VGND.n1831 124.832
R2260 VGND.n435 VGND.n434 124.832
R2261 VGND.n2047 VGND.n65 124.832
R2262 VGND.n1120 VGND.n895 124.832
R2263 VGND.n915 VGND.n914 124.832
R2264 VGND.n796 VGND.n769 124.832
R2265 VGND.n1480 VGND.n685 124.832
R2266 VGND.n2031 VGND.n118 124.832
R2267 VGND.n805 VGND.n804 124.081
R2268 VGND.n1300 VGND.n698 121.743
R2269 VGND.n1317 VGND.t22 119.438
R2270 VGND.n1868 VGND.n208 115.079
R2271 VGND.n1052 VGND.t2 114.784
R2272 VGND.n1102 VGND.t31 112.391
R2273 VGND.n1029 VGND.t31 112.391
R2274 VGND.n1060 VGND.t31 112.391
R2275 VGND.n1907 VGND.n173 110.053
R2276 VGND.n339 VGND.n338 106.733
R2277 VGND.n337 VGND.n336 106.733
R2278 VGND.n335 VGND.n333 106.733
R2279 VGND.n333 VGND.n325 106.733
R2280 VGND.n336 VGND.n335 106.733
R2281 VGND.n339 VGND.n337 106.733
R2282 VGND.n1095 VGND.t31 102.826
R2283 VGND.n1022 VGND.t31 102.826
R2284 VGND.n1053 VGND.t31 102.826
R2285 VGND.t2 VGND.n1051 100.436
R2286 VGND.t29 VGND.n192 99.4714
R2287 VGND.t29 VGND.n1554 99.4714
R2288 VGND.n1568 VGND.n1567 97.2542
R2289 VGND.n1565 VGND.n1564 97.2542
R2290 VGND.n439 VGND.n315 97.2542
R2291 VGND.n1717 VGND.n1716 97.2542
R2292 VGND.n1712 VGND.n1710 97.2542
R2293 VGND.n1721 VGND.n313 97.2542
R2294 VGND.n1711 VGND.n313 97.2542
R2295 VGND.n1710 VGND.n317 97.2542
R2296 VGND.n1718 VGND.n1717 97.2542
R2297 VGND.n440 VGND.n439 97.2542
R2298 VGND.n1566 VGND.n1565 97.2542
R2299 VGND.n1569 VGND.n1568 97.2542
R2300 VGND.n913 VGND.n908 92.2437
R2301 VGND.n913 VGND.n912 92.2437
R2302 VGND.n912 VGND.n909 92.2437
R2303 VGND.n909 VGND.n730 92.2437
R2304 VGND.n1275 VGND.n730 92.2437
R2305 VGND.n1275 VGND.n1274 92.2437
R2306 VGND.n1274 VGND.n1273 92.2437
R2307 VGND.n1273 VGND.n731 92.2437
R2308 VGND.n1266 VGND.n731 92.2437
R2309 VGND.n1266 VGND.n1265 92.2437
R2310 VGND.n1265 VGND.n1264 92.2437
R2311 VGND.n1264 VGND.n735 92.2437
R2312 VGND.n798 VGND.n797 92.2437
R2313 VGND.n797 VGND.n771 92.2437
R2314 VGND.n779 VGND.n771 92.2437
R2315 VGND.n790 VGND.n779 92.2437
R2316 VGND.n790 VGND.n789 92.2437
R2317 VGND.n789 VGND.n788 92.2437
R2318 VGND.n780 VGND.n691 92.2437
R2319 VGND.n1320 VGND.n1319 92.2437
R2320 VGND.n1320 VGND.n686 92.2437
R2321 VGND.n1476 VGND.n686 92.2437
R2322 VGND.n1479 VGND.n1478 92.2437
R2323 VGND.n1479 VGND.n682 92.2437
R2324 VGND.n1485 VGND.n682 92.2437
R2325 VGND.n1486 VGND.n1485 92.2437
R2326 VGND.n1509 VGND.n1486 92.2437
R2327 VGND.n1509 VGND.n1508 92.2437
R2328 VGND.n1508 VGND.n1507 92.2437
R2329 VGND.n1507 VGND.n1487 92.2437
R2330 VGND.n1501 VGND.n1487 92.2437
R2331 VGND.n1501 VGND.n1500 92.2437
R2332 VGND.n1500 VGND.n1499 92.2437
R2333 VGND.n1499 VGND.n1491 92.2437
R2334 VGND.t29 VGND.n447 91.0058
R2335 VGND.n437 VGND.n208 85.617
R2336 VGND.n467 VGND.n314 85.1045
R2337 VGND.n1469 VGND.t36 212.636
R2338 VGND.n1023 VGND.t4 81.3049
R2339 VGND.n1040 VGND.t3 81.3049
R2340 VGND.n207 VGND.t29 209.756
R2341 VGND.n982 VGND.n980 76.3222
R2342 VGND.n979 VGND.n970 76.3222
R2343 VGND.n978 VGND.n972 76.3222
R2344 VGND.n977 VGND.n974 76.3222
R2345 VGND.n986 VGND.n976 76.3222
R2346 VGND.n984 VGND.n232 76.3222
R2347 VGND.n982 VGND.n981 76.3222
R2348 VGND.n979 VGND.n969 76.3222
R2349 VGND.n978 VGND.n971 76.3222
R2350 VGND.n977 VGND.n973 76.3222
R2351 VGND.n976 VGND.n975 76.3222
R2352 VGND.n1827 VGND.n1826 76.3222
R2353 VGND.n238 VGND.n237 76.3222
R2354 VGND.n274 VGND.n273 76.3222
R2355 VGND.n280 VGND.n268 76.3222
R2356 VGND.n282 VGND.n281 76.3222
R2357 VGND.n931 VGND.n929 76.3222
R2358 VGND.n929 VGND.n265 76.3222
R2359 VGND.n283 VGND.n282 76.3222
R2360 VGND.n275 VGND.n268 76.3222
R2361 VGND.n273 VGND.n243 76.3222
R2362 VGND.n237 VGND.n233 76.3222
R2363 VGND.n1832 VGND.n218 76.3222
R2364 VGND.n1836 VGND.n219 76.3222
R2365 VGND.n1844 VGND.n220 76.3222
R2366 VGND.n1848 VGND.n221 76.3222
R2367 VGND.n1857 VGND.n1856 76.3222
R2368 VGND.n1860 VGND.n1859 76.3222
R2369 VGND.n241 VGND.n240 76.3222
R2370 VGND.n1818 VGND.n1817 76.3222
R2371 VGND.n277 VGND.n271 76.3222
R2372 VGND.n288 VGND.n266 76.3222
R2373 VGND.n1756 VGND.n290 76.3222
R2374 VGND.n290 VGND.n289 76.3222
R2375 VGND.n278 VGND.n266 76.3222
R2376 VGND.n271 VGND.n242 76.3222
R2377 VGND.n1819 VGND.n1818 76.3222
R2378 VGND.n240 VGND.n229 76.3222
R2379 VGND.n1691 VGND.n1690 76.3222
R2380 VGND.n1695 VGND.n403 76.3222
R2381 VGND.n1696 VGND.n401 76.3222
R2382 VGND.n1703 VGND.n1702 76.3222
R2383 VGND.n1704 VGND.n309 76.3222
R2384 VGND.n456 VGND.n450 76.3222
R2385 VGND.n452 VGND.n451 76.3222
R2386 VGND.n462 VGND.n449 76.3222
R2387 VGND.n1552 VGND.n1551 76.3222
R2388 VGND.n1547 VGND.n1545 76.3222
R2389 VGND.n1724 VGND.n308 76.3222
R2390 VGND.n1557 VGND.n435 76.3222
R2391 VGND.n444 VGND.n441 76.3222
R2392 VGND.n1560 VGND.n1559 76.3222
R2393 VGND.n445 VGND.n318 76.3222
R2394 VGND.n446 VGND.n312 76.3222
R2395 VGND.n1155 VGND.n1154 76.3222
R2396 VGND.n2084 VGND.n2083 76.3222
R2397 VGND.n41 VGND.n40 76.3222
R2398 VGND.n2072 VGND.n2071 76.3222
R2399 VGND.n2069 VGND.n2068 76.3222
R2400 VGND.n60 VGND.n59 76.3222
R2401 VGND.n2048 VGND.n2047 76.3222
R2402 VGND.n76 VGND.n72 76.3222
R2403 VGND.n90 VGND.n77 76.3222
R2404 VGND.n101 VGND.n78 76.3222
R2405 VGND.n2045 VGND.n2044 76.3222
R2406 VGND.n625 VGND.n74 76.3222
R2407 VGND.n626 VGND.n195 76.3222
R2408 VGND.n668 VGND.n197 76.3222
R2409 VGND.n654 VGND.n198 76.3222
R2410 VGND.n644 VGND.n199 76.3222
R2411 VGND.n1875 VGND.n200 76.3222
R2412 VGND.n1864 VGND.n196 76.3222
R2413 VGND.n201 VGND.n196 76.3222
R2414 VGND.n1875 VGND.n1874 76.3222
R2415 VGND.n638 VGND.n199 76.3222
R2416 VGND.n643 VGND.n198 76.3222
R2417 VGND.n653 VGND.n197 76.3222
R2418 VGND.n667 VGND.n195 76.3222
R2419 VGND.n227 VGND.n226 76.3222
R2420 VGND.n1840 VGND.n1839 76.3222
R2421 VGND.n1841 VGND.n224 76.3222
R2422 VGND.n1852 VGND.n1851 76.3222
R2423 VGND.n1853 VGND.n211 76.3222
R2424 VGND.n1865 VGND.n1863 76.3222
R2425 VGND.n1863 VGND.n1862 76.3222
R2426 VGND.n1854 VGND.n1853 76.3222
R2427 VGND.n1851 VGND.n1850 76.3222
R2428 VGND.n1842 VGND.n1841 76.3222
R2429 VGND.n1839 VGND.n1838 76.3222
R2430 VGND.n226 VGND.n61 76.3222
R2431 VGND.n1835 VGND.n218 76.3222
R2432 VGND.n1843 VGND.n219 76.3222
R2433 VGND.n1847 VGND.n220 76.3222
R2434 VGND.n222 VGND.n221 76.3222
R2435 VGND.n1857 VGND.n214 76.3222
R2436 VGND.n985 VGND.n984 76.3222
R2437 VGND.n1828 VGND.n1827 76.3222
R2438 VGND.n1003 VGND.n1002 76.3222
R2439 VGND.n998 VGND.n966 76.3222
R2440 VGND.n994 VGND.n965 76.3222
R2441 VGND.n990 VGND.n964 76.3222
R2442 VGND.n962 VGND.n56 76.3222
R2443 VGND.n989 VGND.n963 76.3222
R2444 VGND.n993 VGND.n964 76.3222
R2445 VGND.n997 VGND.n965 76.3222
R2446 VGND.n967 VGND.n966 76.3222
R2447 VGND.n1003 VGND.n961 76.3222
R2448 VGND.n1152 VGND.n1151 76.3222
R2449 VGND.n2080 VGND.n32 76.3222
R2450 VGND.n2078 VGND.n2077 76.3222
R2451 VGND.n50 VGND.n47 76.3222
R2452 VGND.n2065 VGND.n53 76.3222
R2453 VGND.n2063 VGND.n2062 76.3222
R2454 VGND.n914 VGND.n726 76.3222
R2455 VGND.n910 VGND.n727 76.3222
R2456 VGND.n1257 VGND.n1256 76.3222
R2457 VGND.n1236 VGND.n743 76.3222
R2458 VGND.n814 VGND.n742 76.3222
R2459 VGND.n1222 VGND.n741 76.3222
R2460 VGND.n873 VGND.n740 76.3222
R2461 VGND.n1223 VGND.n740 76.3222
R2462 VGND.n815 VGND.n741 76.3222
R2463 VGND.n1237 VGND.n742 76.3222
R2464 VGND.n744 VGND.n743 76.3222
R2465 VGND.n1257 VGND.n738 76.3222
R2466 VGND.n1246 VGND.n803 76.3222
R2467 VGND.n1244 VGND.n1243 76.3222
R2468 VGND.n1241 VGND.n1240 76.3222
R2469 VGND.n1229 VGND.n817 76.3222
R2470 VGND.n1227 VGND.n1226 76.3222
R2471 VGND.n876 VGND.n875 76.3222
R2472 VGND.n875 VGND.n819 76.3222
R2473 VGND.n1228 VGND.n1227 76.3222
R2474 VGND.n817 VGND.n809 76.3222
R2475 VGND.n1242 VGND.n1241 76.3222
R2476 VGND.n1245 VGND.n1244 76.3222
R2477 VGND.n2053 VGND.n2052 76.3222
R2478 VGND.n87 VGND.n86 76.3222
R2479 VGND.n97 VGND.n95 76.3222
R2480 VGND.n105 VGND.n83 76.3222
R2481 VGND.n2041 VGND.n107 76.3222
R2482 VGND.n2039 VGND.n2038 76.3222
R2483 VGND.n1452 VGND.n1451 76.3222
R2484 VGND.n1443 VGND.n1342 76.3222
R2485 VGND.n1417 VGND.n1341 76.3222
R2486 VGND.n1428 VGND.n1340 76.3222
R2487 VGND.n1456 VGND.n1339 76.3222
R2488 VGND.n1454 VGND.n109 76.3222
R2489 VGND.n1455 VGND.n1454 76.3222
R2490 VGND.n1427 VGND.n1339 76.3222
R2491 VGND.n1418 VGND.n1340 76.3222
R2492 VGND.n1442 VGND.n1341 76.3222
R2493 VGND.n1343 VGND.n1342 76.3222
R2494 VGND.n1411 VGND.n1326 76.3222
R2495 VGND.n1439 VGND.n1327 76.3222
R2496 VGND.n1422 VGND.n1328 76.3222
R2497 VGND.n1336 VGND.n1329 76.3222
R2498 VGND.n1468 VGND.n1467 76.3222
R2499 VGND.n1468 VGND.n1330 76.3222
R2500 VGND.n1423 VGND.n1329 76.3222
R2501 VGND.n1438 VGND.n1328 76.3222
R2502 VGND.n1412 VGND.n1327 76.3222
R2503 VGND.n1326 VGND.n1325 76.3222
R2504 VGND.n1493 VGND.n167 76.3222
R2505 VGND.n1992 VGND.n1991 76.3222
R2506 VGND.n1984 VGND.n1918 76.3222
R2507 VGND.n1982 VGND.n1981 76.3222
R2508 VGND.n2002 VGND.n143 76.3222
R2509 VGND.n2006 VGND.n141 76.3222
R2510 VGND.n1452 VGND.n688 76.3222
R2511 VGND.n803 VGND.n802 76.3222
R2512 VGND.n911 VGND.n726 76.3222
R2513 VGND.n728 VGND.n727 76.3222
R2514 VGND.n1705 VGND.n1704 76.3222
R2515 VGND.n1702 VGND.n1701 76.3222
R2516 VGND.n1697 VGND.n1696 76.3222
R2517 VGND.n1692 VGND.n403 76.3222
R2518 VGND.n1690 VGND.n1689 76.3222
R2519 VGND.n1546 VGND.n308 76.3222
R2520 VGND.n1550 VGND.n1545 76.3222
R2521 VGND.n1553 VGND.n1552 76.3222
R2522 VGND.n462 VGND.n461 76.3222
R2523 VGND.n457 VGND.n451 76.3222
R2524 VGND.n453 VGND.n450 76.3222
R2525 VGND.n1557 VGND.n1556 76.3222
R2526 VGND.n444 VGND.n442 76.3222
R2527 VGND.n1559 VGND.n443 76.3222
R2528 VGND.n445 VGND.n319 76.3222
R2529 VGND.n446 VGND.n321 76.3222
R2530 VGND.n1859 VGND.n215 76.3222
R2531 VGND.n662 VGND.n661 76.3222
R2532 VGND.n659 VGND.n658 76.3222
R2533 VGND.n649 VGND.n648 76.3222
R2534 VGND.n636 VGND.n632 76.3222
R2535 VGND.n1871 VGND.n204 76.3222
R2536 VGND.n1869 VGND.n1868 76.3222
R2537 VGND.n1870 VGND.n1869 76.3222
R2538 VGND.n635 VGND.n204 76.3222
R2539 VGND.n632 VGND.n628 76.3222
R2540 VGND.n650 VGND.n649 76.3222
R2541 VGND.n660 VGND.n659 76.3222
R2542 VGND.n2003 VGND.n141 76.3222
R2543 VGND.n1920 VGND.n143 76.3222
R2544 VGND.n1983 VGND.n1982 76.3222
R2545 VGND.n1918 VGND.n169 76.3222
R2546 VGND.n1993 VGND.n1992 76.3222
R2547 VGND.n1494 VGND.n1493 76.3222
R2548 VGND.n663 VGND.n662 76.3222
R2549 VGND.n2040 VGND.n2039 76.3222
R2550 VGND.n107 VGND.n106 76.3222
R2551 VGND.n96 VGND.n83 76.3222
R2552 VGND.n95 VGND.n94 76.3222
R2553 VGND.n86 VGND.n70 76.3222
R2554 VGND.n2054 VGND.n2053 76.3222
R2555 VGND.n2049 VGND.n2048 76.3222
R2556 VGND.n91 VGND.n76 76.3222
R2557 VGND.n100 VGND.n77 76.3222
R2558 VGND.n80 VGND.n78 76.3222
R2559 VGND.n2045 VGND.n79 76.3222
R2560 VGND.n111 VGND.n74 76.3222
R2561 VGND.n59 VGND.n43 76.3222
R2562 VGND.n2070 VGND.n2069 76.3222
R2563 VGND.n2073 VGND.n2072 76.3222
R2564 VGND.n40 VGND.n29 76.3222
R2565 VGND.n2085 VGND.n2084 76.3222
R2566 VGND.n1154 VGND.n27 76.3222
R2567 VGND.n2064 VGND.n2063 76.3222
R2568 VGND.n53 VGND.n52 76.3222
R2569 VGND.n47 VGND.n35 76.3222
R2570 VGND.n2079 VGND.n2078 76.3222
R2571 VGND.n1149 VGND.n32 76.3222
R2572 VGND.n1151 VGND.n1150 76.3222
R2573 VGND.n1897 VGND.t20 76.191
R2574 VGND.n1896 VGND.n184 76.191
R2575 VGND.n1719 VGND.n315 75.1716
R2576 VGND.n1997 VGND.n1996 74.5978
R2577 VGND.n1997 VGND.n163 74.5978
R2578 VGND.n1902 VGND.n179 74.5978
R2579 VGND.n382 VGND.n342 74.5978
R2580 VGND.n1251 VGND.n747 74.5978
R2581 VGND.n1251 VGND.n1250 74.5978
R2582 VGND.n1823 VGND.n235 74.5978
R2583 VGND.n1798 VGND.n235 74.5978
R2584 VGND.n1642 VGND.n1639 74.5978
R2585 VGND.n1639 VGND.n1638 74.5978
R2586 VGND.n672 VGND.n671 74.5978
R2587 VGND.n672 VGND.n562 74.5978
R2588 VGND.n1447 VGND.n1408 74.5978
R2589 VGND.n1408 VGND.n1407 74.5978
R2590 VGND.n342 VGND.n341 74.5978
R2591 VGND.n488 VGND.n179 74.5978
R2592 VGND.n2089 VGND.n2088 74.5978
R2593 VGND.n2089 VGND.n23 74.5978
R2594 VGND.t27 VGND.n190 71.9582
R2595 VGND.n1877 VGND.t29 69.8418
R2596 VGND.n1954 VGND.n152 69.3109
R2597 VGND.n1957 VGND.n152 69.3109
R2598 VGND.n529 VGND.n475 69.3109
R2599 VGND.n364 VGND.n329 69.3109
R2600 VGND.n361 VGND.n329 69.3109
R2601 VGND.n855 VGND.n754 69.3109
R2602 VGND.n858 VGND.n754 69.3109
R2603 VGND.n1779 VGND.n251 69.3109
R2604 VGND.n1776 VGND.n251 69.3109
R2605 VGND.n1604 VGND.n1603 69.3109
R2606 VGND.n1603 VGND.n1602 69.3109
R2607 VGND.n587 VGND.n551 69.3109
R2608 VGND.n584 VGND.n551 69.3109
R2609 VGND.n1373 VGND.n1372 69.3109
R2610 VGND.n1372 VGND.n1371 69.3109
R2611 VGND.n531 VGND.n475 69.3109
R2612 VGND.n1178 VGND.n12 69.3109
R2613 VGND.n1175 VGND.n12 69.3109
R2614 VGND.n2058 VGND.t29 67.8333
R2615 VGND.n190 VGND.n184 67.7254
R2616 VGND.n1727 VGND.n1726 67.1761
R2617 VGND.n933 VGND.t31 67.1761
R2618 VGND.t31 VGND.n34 66.1603
R2619 VGND.n1910 VGND.n1909 66.0645
R2620 VGND.t39 VGND.n162 65.8183
R2621 VGND.t39 VGND.n161 65.8183
R2622 VGND.t39 VGND.n160 65.8183
R2623 VGND.t39 VGND.n159 65.8183
R2624 VGND.t39 VGND.n151 65.8183
R2625 VGND.t39 VGND.n157 65.8183
R2626 VGND.t39 VGND.n148 65.8183
R2627 VGND.t39 VGND.n158 65.8183
R2628 VGND.t39 VGND.n156 65.8183
R2629 VGND.t39 VGND.n155 65.8183
R2630 VGND.t39 VGND.n154 65.8183
R2631 VGND.t39 VGND.n153 65.8183
R2632 VGND.t37 VGND.n396 65.8183
R2633 VGND.t37 VGND.n345 65.8183
R2634 VGND.t37 VGND.n344 65.8183
R2635 VGND.t37 VGND.n343 65.8183
R2636 VGND.t37 VGND.n328 65.8183
R2637 VGND.t37 VGND.n334 65.8183
R2638 VGND.t37 VGND.n327 65.8183
R2639 VGND.t37 VGND.n340 65.8183
R2640 VGND.t37 VGND.n324 65.8183
R2641 VGND.t37 VGND.n332 65.8183
R2642 VGND.t37 VGND.n331 65.8183
R2643 VGND.t37 VGND.n330 65.8183
R2644 VGND.t33 VGND.n764 65.8183
R2645 VGND.t33 VGND.n763 65.8183
R2646 VGND.t33 VGND.n762 65.8183
R2647 VGND.t33 VGND.n761 65.8183
R2648 VGND.t33 VGND.n752 65.8183
R2649 VGND.t33 VGND.n759 65.8183
R2650 VGND.t33 VGND.n749 65.8183
R2651 VGND.t33 VGND.n760 65.8183
R2652 VGND.t33 VGND.n758 65.8183
R2653 VGND.t33 VGND.n757 65.8183
R2654 VGND.t33 VGND.n756 65.8183
R2655 VGND.t33 VGND.n755 65.8183
R2656 VGND.t33 VGND.n753 65.8183
R2657 VGND.t33 VGND.n751 65.8183
R2658 VGND.t33 VGND.n750 65.8183
R2659 VGND.n1252 VGND.t33 65.8183
R2660 VGND.t30 VGND.n1812 65.8183
R2661 VGND.t30 VGND.n260 65.8183
R2662 VGND.t30 VGND.n259 65.8183
R2663 VGND.t30 VGND.n258 65.8183
R2664 VGND.t30 VGND.n249 65.8183
R2665 VGND.t30 VGND.n256 65.8183
R2666 VGND.t30 VGND.n247 65.8183
R2667 VGND.t30 VGND.n257 65.8183
R2668 VGND.t30 VGND.n255 65.8183
R2669 VGND.t30 VGND.n254 65.8183
R2670 VGND.t30 VGND.n253 65.8183
R2671 VGND.t30 VGND.n252 65.8183
R2672 VGND.t30 VGND.n250 65.8183
R2673 VGND.t30 VGND.n248 65.8183
R2674 VGND.n1813 VGND.t30 65.8183
R2675 VGND.t30 VGND.n236 65.8183
R2676 VGND.n1623 VGND.t34 65.8183
R2677 VGND.n1625 VGND.t34 65.8183
R2678 VGND.n1631 VGND.t34 65.8183
R2679 VGND.n1633 VGND.t34 65.8183
R2680 VGND.n1583 VGND.t34 65.8183
R2681 VGND.n1609 VGND.t34 65.8183
R2682 VGND.n1615 VGND.t34 65.8183
R2683 VGND.n1617 VGND.t34 65.8183
R2684 VGND.t34 VGND.n412 65.8183
R2685 VGND.n1589 VGND.t34 65.8183
R2686 VGND.n1596 VGND.t34 65.8183
R2687 VGND.n1587 VGND.t34 65.8183
R2688 VGND.n1674 VGND.t34 65.8183
R2689 VGND.n1661 VGND.t34 65.8183
R2690 VGND.n1659 VGND.t34 65.8183
R2691 VGND.n1640 VGND.t34 65.8183
R2692 VGND.t28 VGND.n561 65.8183
R2693 VGND.t28 VGND.n560 65.8183
R2694 VGND.t28 VGND.n559 65.8183
R2695 VGND.t28 VGND.n558 65.8183
R2696 VGND.t28 VGND.n549 65.8183
R2697 VGND.t28 VGND.n556 65.8183
R2698 VGND.t28 VGND.n547 65.8183
R2699 VGND.t28 VGND.n557 65.8183
R2700 VGND.t28 VGND.n555 65.8183
R2701 VGND.t28 VGND.n554 65.8183
R2702 VGND.t28 VGND.n553 65.8183
R2703 VGND.t28 VGND.n552 65.8183
R2704 VGND.t28 VGND.n550 65.8183
R2705 VGND.t28 VGND.n548 65.8183
R2706 VGND.n673 VGND.t28 65.8183
R2707 VGND.t28 VGND.n546 65.8183
R2708 VGND.n1392 VGND.t35 65.8183
R2709 VGND.n1394 VGND.t35 65.8183
R2710 VGND.n1400 VGND.t35 65.8183
R2711 VGND.n1402 VGND.t35 65.8183
R2712 VGND.n1352 VGND.t35 65.8183
R2713 VGND.n1378 VGND.t35 65.8183
R2714 VGND.n1384 VGND.t35 65.8183
R2715 VGND.n1386 VGND.t35 65.8183
R2716 VGND.t35 VGND.n1333 65.8183
R2717 VGND.n1358 VGND.t35 65.8183
R2718 VGND.n1365 VGND.t35 65.8183
R2719 VGND.n1356 VGND.t35 65.8183
R2720 VGND.n1460 VGND.t35 65.8183
R2721 VGND.n1420 VGND.t35 65.8183
R2722 VGND.n1434 VGND.t35 65.8183
R2723 VGND.n1409 VGND.t35 65.8183
R2724 VGND.n325 VGND.n310 65.8183
R2725 VGND.n335 VGND.n310 65.8183
R2726 VGND.t37 VGND.n333 65.8183
R2727 VGND.n337 VGND.n310 65.8183
R2728 VGND.t37 VGND.n336 65.8183
R2729 VGND.n338 VGND.n310 65.8183
R2730 VGND.t37 VGND.n339 65.8183
R2731 VGND.t38 VGND.n482 65.8183
R2732 VGND.t38 VGND.n180 65.8183
R2733 VGND.t38 VGND.n477 65.8183
R2734 VGND.t38 VGND.n478 65.8183
R2735 VGND.t38 VGND.n479 65.8183
R2736 VGND.t38 VGND.n480 65.8183
R2737 VGND.t38 VGND.n536 65.8183
R2738 VGND.t38 VGND.n483 65.8183
R2739 VGND.t38 VGND.n481 65.8183
R2740 VGND.t38 VGND.n476 65.8183
R2741 VGND.t38 VGND.n470 65.8183
R2742 VGND.t38 VGND.n472 65.8183
R2743 VGND.t38 VGND.n473 65.8183
R2744 VGND.t38 VGND.n474 65.8183
R2745 VGND.t38 VGND.n1533 65.8183
R2746 VGND.n1998 VGND.t39 65.8183
R2747 VGND.t39 VGND.n150 65.8183
R2748 VGND.t39 VGND.n149 65.8183
R2749 VGND.t39 VGND.n147 65.8183
R2750 VGND.t32 VGND.n22 65.8183
R2751 VGND.t32 VGND.n21 65.8183
R2752 VGND.t32 VGND.n20 65.8183
R2753 VGND.t32 VGND.n19 65.8183
R2754 VGND.t32 VGND.n10 65.8183
R2755 VGND.t32 VGND.n17 65.8183
R2756 VGND.t32 VGND.n8 65.8183
R2757 VGND.t32 VGND.n18 65.8183
R2758 VGND.t32 VGND.n16 65.8183
R2759 VGND.t32 VGND.n15 65.8183
R2760 VGND.t32 VGND.n14 65.8183
R2761 VGND.t32 VGND.n13 65.8183
R2762 VGND.t32 VGND.n11 65.8183
R2763 VGND.n2090 VGND.t32 65.8183
R2764 VGND.t32 VGND.n9 65.8183
R2765 VGND.t32 VGND.n7 65.8183
R2766 VGND.n1319 VGND.n1318 64.5707
R2767 VGND.n1906 VGND.n174 63.4926
R2768 VGND.n696 VGND.n693 63.0593
R2769 VGND.n780 VGND.t36 62.5209
R2770 VGND.n2009 VGND.n140 62.4163
R2771 VGND.t6 VGND.n1102 62.1744
R2772 VGND.n2008 VGND.t36 58.4076
R2773 VGND.n1147 VGND.t31 58.1503
R2774 VGND.t39 VGND.n152 57.8461
R2775 VGND.t37 VGND.n329 57.8461
R2776 VGND.t33 VGND.n754 57.8461
R2777 VGND.t30 VGND.n251 57.8461
R2778 VGND.n1603 VGND.t34 57.8461
R2779 VGND.t28 VGND.n551 57.8461
R2780 VGND.n1372 VGND.t35 57.8461
R2781 VGND.t38 VGND.n475 57.8461
R2782 VGND.t32 VGND.n12 57.8461
R2783 VGND.n916 VGND.t31 57.3918
R2784 VGND.t37 VGND.n342 55.2026
R2785 VGND.t33 VGND.n1251 55.2026
R2786 VGND.t30 VGND.n235 55.2026
R2787 VGND.n1639 VGND.t34 55.2026
R2788 VGND.t28 VGND.n672 55.2026
R2789 VGND.n1408 VGND.t35 55.2026
R2790 VGND.t38 VGND.n179 55.2026
R2791 VGND.t39 VGND.n1997 55.2026
R2792 VGND.t32 VGND.n2089 55.2026
R2793 VGND.n1279 VGND.n1278 54.0532
R2794 VGND.n1938 VGND.n158 53.3664
R2795 VGND.n1942 VGND.n148 53.3664
R2796 VGND.n1946 VGND.n157 53.3664
R2797 VGND.n1950 VGND.n151 53.3664
R2798 VGND.n1961 VGND.n153 53.3664
R2799 VGND.n1965 VGND.n154 53.3664
R2800 VGND.n1969 VGND.n155 53.3664
R2801 VGND.n1972 VGND.n156 53.3664
R2802 VGND.n164 VGND.n147 53.3664
R2803 VGND.n1987 VGND.n149 53.3664
R2804 VGND.n1977 VGND.n150 53.3664
R2805 VGND.n1999 VGND.n1998 53.3664
R2806 VGND.n1934 VGND.n162 53.3664
R2807 VGND.n1933 VGND.n161 53.3664
R2808 VGND.n1929 VGND.n160 53.3664
R2809 VGND.n1925 VGND.n159 53.3664
R2810 VGND.n1937 VGND.n162 53.3664
R2811 VGND.n1930 VGND.n161 53.3664
R2812 VGND.n1926 VGND.n160 53.3664
R2813 VGND.n1922 VGND.n159 53.3664
R2814 VGND.n1953 VGND.n151 53.3664
R2815 VGND.n1949 VGND.n157 53.3664
R2816 VGND.n1945 VGND.n148 53.3664
R2817 VGND.n1941 VGND.n158 53.3664
R2818 VGND.n1970 VGND.n156 53.3664
R2819 VGND.n1966 VGND.n155 53.3664
R2820 VGND.n1962 VGND.n154 53.3664
R2821 VGND.n1958 VGND.n153 53.3664
R2822 VGND.n504 VGND.n477 53.3664
R2823 VGND.n500 VGND.n478 53.3664
R2824 VGND.n496 VGND.n479 53.3664
R2825 VGND.n492 VGND.n480 53.3664
R2826 VGND.n505 VGND.n476 53.3664
R2827 VGND.n509 VGND.n481 53.3664
R2828 VGND.n513 VGND.n483 53.3664
R2829 VGND.n536 VGND.n535 53.3664
R2830 VGND.n525 VGND.n474 53.3664
R2831 VGND.n521 VGND.n473 53.3664
R2832 VGND.n517 VGND.n472 53.3664
R2833 VGND.n1535 VGND.n470 53.3664
R2834 VGND.n1901 VGND.n180 53.3664
R2835 VGND.n1517 VGND.n482 53.3664
R2836 VGND.n1533 VGND.n471 53.3664
R2837 VGND.n396 VGND.n395 53.3664
R2838 VGND.n347 VGND.n345 53.3664
R2839 VGND.n390 VGND.n344 53.3664
R2840 VGND.n386 VGND.n343 53.3664
R2841 VGND.n396 VGND.n346 53.3664
R2842 VGND.n391 VGND.n345 53.3664
R2843 VGND.n387 VGND.n344 53.3664
R2844 VGND.n383 VGND.n343 53.3664
R2845 VGND.n379 VGND.n340 53.3664
R2846 VGND.n376 VGND.n327 53.3664
R2847 VGND.n372 VGND.n334 53.3664
R2848 VGND.n368 VGND.n328 53.3664
R2849 VGND.n365 VGND.n328 53.3664
R2850 VGND.n369 VGND.n334 53.3664
R2851 VGND.n373 VGND.n327 53.3664
R2852 VGND.n377 VGND.n340 53.3664
R2853 VGND.n357 VGND.n330 53.3664
R2854 VGND.n353 VGND.n331 53.3664
R2855 VGND.n349 VGND.n332 53.3664
R2856 VGND.n398 VGND.n324 53.3664
R2857 VGND.n348 VGND.n324 53.3664
R2858 VGND.n352 VGND.n332 53.3664
R2859 VGND.n356 VGND.n331 53.3664
R2860 VGND.n360 VGND.n330 53.3664
R2861 VGND.n397 VGND.n325 53.3664
R2862 VGND.n839 VGND.n760 53.3664
R2863 VGND.n843 VGND.n749 53.3664
R2864 VGND.n847 VGND.n759 53.3664
R2865 VGND.n851 VGND.n752 53.3664
R2866 VGND.n862 VGND.n755 53.3664
R2867 VGND.n866 VGND.n756 53.3664
R2868 VGND.n870 VGND.n757 53.3664
R2869 VGND.n1218 VGND.n758 53.3664
R2870 VGND.n1253 VGND.n1252 53.3664
R2871 VGND.n810 VGND.n750 53.3664
R2872 VGND.n1232 VGND.n751 53.3664
R2873 VGND.n822 VGND.n753 53.3664
R2874 VGND.n835 VGND.n764 53.3664
R2875 VGND.n834 VGND.n763 53.3664
R2876 VGND.n830 VGND.n762 53.3664
R2877 VGND.n826 VGND.n761 53.3664
R2878 VGND.n838 VGND.n764 53.3664
R2879 VGND.n831 VGND.n763 53.3664
R2880 VGND.n827 VGND.n762 53.3664
R2881 VGND.n765 VGND.n761 53.3664
R2882 VGND.n854 VGND.n752 53.3664
R2883 VGND.n850 VGND.n759 53.3664
R2884 VGND.n846 VGND.n749 53.3664
R2885 VGND.n842 VGND.n760 53.3664
R2886 VGND.n871 VGND.n758 53.3664
R2887 VGND.n867 VGND.n757 53.3664
R2888 VGND.n863 VGND.n756 53.3664
R2889 VGND.n859 VGND.n755 53.3664
R2890 VGND.n1219 VGND.n753 53.3664
R2891 VGND.n821 VGND.n751 53.3664
R2892 VGND.n1233 VGND.n750 53.3664
R2893 VGND.n1252 VGND.n748 53.3664
R2894 VGND.n1794 VGND.n257 53.3664
R2895 VGND.n1791 VGND.n247 53.3664
R2896 VGND.n1787 VGND.n256 53.3664
R2897 VGND.n1783 VGND.n249 53.3664
R2898 VGND.n1772 VGND.n252 53.3664
R2899 VGND.n1768 VGND.n253 53.3664
R2900 VGND.n1764 VGND.n254 53.3664
R2901 VGND.n1760 VGND.n255 53.3664
R2902 VGND.n1822 VGND.n236 53.3664
R2903 VGND.n1814 VGND.n1813 53.3664
R2904 VGND.n269 VGND.n248 53.3664
R2905 VGND.n285 VGND.n250 53.3664
R2906 VGND.n1812 VGND.n1811 53.3664
R2907 VGND.n262 VGND.n260 53.3664
R2908 VGND.n1806 VGND.n259 53.3664
R2909 VGND.n1802 VGND.n258 53.3664
R2910 VGND.n1812 VGND.n261 53.3664
R2911 VGND.n1807 VGND.n260 53.3664
R2912 VGND.n1803 VGND.n259 53.3664
R2913 VGND.n1799 VGND.n258 53.3664
R2914 VGND.n1780 VGND.n249 53.3664
R2915 VGND.n1784 VGND.n256 53.3664
R2916 VGND.n1788 VGND.n247 53.3664
R2917 VGND.n1792 VGND.n257 53.3664
R2918 VGND.n1763 VGND.n255 53.3664
R2919 VGND.n1767 VGND.n254 53.3664
R2920 VGND.n1771 VGND.n253 53.3664
R2921 VGND.n1775 VGND.n252 53.3664
R2922 VGND.n1759 VGND.n250 53.3664
R2923 VGND.n284 VGND.n248 53.3664
R2924 VGND.n1813 VGND.n246 53.3664
R2925 VGND.n245 VGND.n236 53.3664
R2926 VGND.n1617 VGND.n1580 53.3664
R2927 VGND.n1616 VGND.n1615 53.3664
R2928 VGND.n1609 VGND.n1582 53.3664
R2929 VGND.n1608 VGND.n1583 53.3664
R2930 VGND.n1598 VGND.n1587 53.3664
R2931 VGND.n1596 VGND.n1595 53.3664
R2932 VGND.n1591 VGND.n1589 53.3664
R2933 VGND.n1676 VGND.n412 53.3664
R2934 VGND.n1641 VGND.n1640 53.3664
R2935 VGND.n1659 VGND.n1658 53.3664
R2936 VGND.n1662 VGND.n1661 53.3664
R2937 VGND.n1674 VGND.n1673 53.3664
R2938 VGND.n1624 VGND.n1623 53.3664
R2939 VGND.n1626 VGND.n1625 53.3664
R2940 VGND.n1631 VGND.n1630 53.3664
R2941 VGND.n1634 VGND.n1633 53.3664
R2942 VGND.n1623 VGND.n1622 53.3664
R2943 VGND.n1625 VGND.n1578 53.3664
R2944 VGND.n1632 VGND.n1631 53.3664
R2945 VGND.n1633 VGND.n1576 53.3664
R2946 VGND.n1605 VGND.n1583 53.3664
R2947 VGND.n1610 VGND.n1609 53.3664
R2948 VGND.n1615 VGND.n1614 53.3664
R2949 VGND.n1618 VGND.n1617 53.3664
R2950 VGND.n1590 VGND.n412 53.3664
R2951 VGND.n1589 VGND.n1588 53.3664
R2952 VGND.n1597 VGND.n1596 53.3664
R2953 VGND.n1587 VGND.n1585 53.3664
R2954 VGND.n1675 VGND.n1674 53.3664
R2955 VGND.n1661 VGND.n413 53.3664
R2956 VGND.n1660 VGND.n1659 53.3664
R2957 VGND.n1640 VGND.n419 53.3664
R2958 VGND.n603 VGND.n557 53.3664
R2959 VGND.n599 VGND.n547 53.3664
R2960 VGND.n595 VGND.n556 53.3664
R2961 VGND.n591 VGND.n549 53.3664
R2962 VGND.n580 VGND.n552 53.3664
R2963 VGND.n576 VGND.n553 53.3664
R2964 VGND.n572 VGND.n554 53.3664
R2965 VGND.n568 VGND.n555 53.3664
R2966 VGND.n563 VGND.n546 53.3664
R2967 VGND.n674 VGND.n673 53.3664
R2968 VGND.n640 VGND.n548 53.3664
R2969 VGND.n629 VGND.n550 53.3664
R2970 VGND.n607 VGND.n561 53.3664
R2971 VGND.n608 VGND.n560 53.3664
R2972 VGND.n612 VGND.n559 53.3664
R2973 VGND.n616 VGND.n558 53.3664
R2974 VGND.n604 VGND.n561 53.3664
R2975 VGND.n611 VGND.n560 53.3664
R2976 VGND.n615 VGND.n559 53.3664
R2977 VGND.n618 VGND.n558 53.3664
R2978 VGND.n588 VGND.n549 53.3664
R2979 VGND.n592 VGND.n556 53.3664
R2980 VGND.n596 VGND.n547 53.3664
R2981 VGND.n600 VGND.n557 53.3664
R2982 VGND.n571 VGND.n555 53.3664
R2983 VGND.n575 VGND.n554 53.3664
R2984 VGND.n579 VGND.n553 53.3664
R2985 VGND.n583 VGND.n552 53.3664
R2986 VGND.n567 VGND.n550 53.3664
R2987 VGND.n630 VGND.n548 53.3664
R2988 VGND.n673 VGND.n545 53.3664
R2989 VGND.n546 VGND.n544 53.3664
R2990 VGND.n1386 VGND.n1349 53.3664
R2991 VGND.n1385 VGND.n1384 53.3664
R2992 VGND.n1378 VGND.n1351 53.3664
R2993 VGND.n1377 VGND.n1352 53.3664
R2994 VGND.n1367 VGND.n1356 53.3664
R2995 VGND.n1365 VGND.n1364 53.3664
R2996 VGND.n1360 VGND.n1358 53.3664
R2997 VGND.n1462 VGND.n1333 53.3664
R2998 VGND.n1446 VGND.n1409 53.3664
R2999 VGND.n1434 VGND.n1433 53.3664
R3000 VGND.n1431 VGND.n1420 53.3664
R3001 VGND.n1460 VGND.n1459 53.3664
R3002 VGND.n1393 VGND.n1392 53.3664
R3003 VGND.n1395 VGND.n1394 53.3664
R3004 VGND.n1400 VGND.n1399 53.3664
R3005 VGND.n1403 VGND.n1402 53.3664
R3006 VGND.n1392 VGND.n1391 53.3664
R3007 VGND.n1394 VGND.n1347 53.3664
R3008 VGND.n1401 VGND.n1400 53.3664
R3009 VGND.n1402 VGND.n1345 53.3664
R3010 VGND.n1374 VGND.n1352 53.3664
R3011 VGND.n1379 VGND.n1378 53.3664
R3012 VGND.n1384 VGND.n1383 53.3664
R3013 VGND.n1387 VGND.n1386 53.3664
R3014 VGND.n1359 VGND.n1333 53.3664
R3015 VGND.n1358 VGND.n1357 53.3664
R3016 VGND.n1366 VGND.n1365 53.3664
R3017 VGND.n1356 VGND.n1354 53.3664
R3018 VGND.n1461 VGND.n1460 53.3664
R3019 VGND.n1420 VGND.n1335 53.3664
R3020 VGND.n1435 VGND.n1434 53.3664
R3021 VGND.n1432 VGND.n1409 53.3664
R3022 VGND.n338 VGND.n326 53.3664
R3023 VGND.n1533 VGND.n1532 53.3664
R3024 VGND.n1520 VGND.n482 53.3664
R3025 VGND.n1516 VGND.n180 53.3664
R3026 VGND.n501 VGND.n477 53.3664
R3027 VGND.n497 VGND.n478 53.3664
R3028 VGND.n493 VGND.n479 53.3664
R3029 VGND.n489 VGND.n480 53.3664
R3030 VGND.n536 VGND.n485 53.3664
R3031 VGND.n486 VGND.n483 53.3664
R3032 VGND.n512 VGND.n481 53.3664
R3033 VGND.n508 VGND.n476 53.3664
R3034 VGND.n516 VGND.n470 53.3664
R3035 VGND.n520 VGND.n472 53.3664
R3036 VGND.n524 VGND.n473 53.3664
R3037 VGND.n528 VGND.n474 53.3664
R3038 VGND.n1998 VGND.n146 53.3664
R3039 VGND.n150 VGND.n145 53.3664
R3040 VGND.n1976 VGND.n149 53.3664
R3041 VGND.n1988 VGND.n147 53.3664
R3042 VGND.n1194 VGND.n18 53.3664
R3043 VGND.n1190 VGND.n8 53.3664
R3044 VGND.n1186 VGND.n17 53.3664
R3045 VGND.n1182 VGND.n10 53.3664
R3046 VGND.n1171 VGND.n13 53.3664
R3047 VGND.n1167 VGND.n14 53.3664
R3048 VGND.n1163 VGND.n15 53.3664
R3049 VGND.n1159 VGND.n16 53.3664
R3050 VGND.n24 VGND.n7 53.3664
R3051 VGND.n37 VGND.n9 53.3664
R3052 VGND.n2091 VGND.n2090 53.3664
R3053 VGND.n44 VGND.n11 53.3664
R3054 VGND.n1198 VGND.n22 53.3664
R3055 VGND.n1199 VGND.n21 53.3664
R3056 VGND.n1203 VGND.n20 53.3664
R3057 VGND.n1207 VGND.n19 53.3664
R3058 VGND.n1195 VGND.n22 53.3664
R3059 VGND.n1202 VGND.n21 53.3664
R3060 VGND.n1206 VGND.n20 53.3664
R3061 VGND.n1209 VGND.n19 53.3664
R3062 VGND.n1179 VGND.n10 53.3664
R3063 VGND.n1183 VGND.n17 53.3664
R3064 VGND.n1187 VGND.n8 53.3664
R3065 VGND.n1191 VGND.n18 53.3664
R3066 VGND.n1162 VGND.n16 53.3664
R3067 VGND.n1166 VGND.n15 53.3664
R3068 VGND.n1170 VGND.n14 53.3664
R3069 VGND.n1174 VGND.n13 53.3664
R3070 VGND.n1158 VGND.n11 53.3664
R3071 VGND.n2090 VGND.n6 53.3664
R3072 VGND.n9 VGND.n5 53.3664
R3073 VGND.n36 VGND.n7 53.3664
R3074 VGND.n0 VGND.n173 52.9166
R3075 VGND.n1879 VGND.n188 51.1378
R3076 VGND.t18 VGND.n1906 50.7942
R3077 VGND.n191 VGND.t27 50.7942
R3078 VGND.n1070 VGND.t1 47.8266
R3079 VGND.n705 VGND.n704 42.0821
R3080 VGND.n1286 VGND.n706 42.0821
R3081 VGND.n1912 VGND.t26 40.8142
R3082 VGND.n1292 VGND.t15 40.8142
R3083 VGND.t20 VGND.n1896 38.0957
R3084 VGND.n1288 VGND.t16 36.7001
R3085 VGND.t36 VGND.t25 35.0627
R3086 VGND.n1912 VGND 33.275
R3087 VGND.n1292 VGND 33.275
R3088 VGND.n1118 VGND.t5 31.0875
R3089 VGND.t17 VGND.n705 30.9428
R3090 VGND.t14 VGND.n1288 30.0275
R3091 VGND.n788 VGND.t36 29.7233
R3092 VGND.n1907 VGND.t18 29.6301
R3093 VGND.n1897 VGND.n183 29.6301
R3094 VGND.n1318 VGND.n691 27.6735
R3095 VGND.n1299 VGND.n1298 24.1372
R3096 VGND.n1956 VGND.n1955 23.6449
R3097 VGND.n363 VGND.n362 23.6449
R3098 VGND.n857 VGND.n856 23.6449
R3099 VGND.n1778 VGND.n1777 23.6449
R3100 VGND.n1601 VGND.n1584 23.6449
R3101 VGND.n586 VGND.n585 23.6449
R3102 VGND.n1370 VGND.n1353 23.6449
R3103 VGND.n532 VGND.n530 23.6449
R3104 VGND.n1177 VGND.n1176 23.6449
R3105 VGND.t21 VGND.n1286 21.6601
R3106 VGND.n1877 VGND.n191 21.1645
R3107 VGND.t21 VGND.n1287 19.9347
R3108 VGND.n1939 VGND.n1936 17.4227
R3109 VGND.n381 VGND.n380 17.4227
R3110 VGND.n840 VGND.n837 17.4227
R3111 VGND.n1796 VGND.n1795 17.4227
R3112 VGND.n1621 VGND.n1620 17.4227
R3113 VGND.n605 VGND.n602 17.4227
R3114 VGND.n1390 VGND.n1389 17.4227
R3115 VGND.n506 VGND.n503 17.4227
R3116 VGND.n1196 VGND.n1193 17.4227
R3117 VGND.n62 VGND.n28 16.9587
R3118 VGND.n1936 VGND.n1935 16.0005
R3119 VGND.n1935 VGND.n1932 16.0005
R3120 VGND.n1932 VGND.n1931 16.0005
R3121 VGND.n1931 VGND.n1928 16.0005
R3122 VGND.n1928 VGND.n1927 16.0005
R3123 VGND.n1927 VGND.n1924 16.0005
R3124 VGND.n1924 VGND.n1923 16.0005
R3125 VGND.n1923 VGND.n1921 16.0005
R3126 VGND.n1940 VGND.n1939 16.0005
R3127 VGND.n1943 VGND.n1940 16.0005
R3128 VGND.n1944 VGND.n1943 16.0005
R3129 VGND.n1947 VGND.n1944 16.0005
R3130 VGND.n1948 VGND.n1947 16.0005
R3131 VGND.n1952 VGND.n1951 16.0005
R3132 VGND.n1955 VGND.n1952 16.0005
R3133 VGND.n1959 VGND.n1956 16.0005
R3134 VGND.n1960 VGND.n1959 16.0005
R3135 VGND.n1963 VGND.n1960 16.0005
R3136 VGND.n1964 VGND.n1963 16.0005
R3137 VGND.n1967 VGND.n1964 16.0005
R3138 VGND.n1968 VGND.n1967 16.0005
R3139 VGND.n1971 VGND.n1968 16.0005
R3140 VGND.n1973 VGND.n1971 16.0005
R3141 VGND.n380 VGND.n378 16.0005
R3142 VGND.n378 VGND.n375 16.0005
R3143 VGND.n375 VGND.n374 16.0005
R3144 VGND.n374 VGND.n371 16.0005
R3145 VGND.n371 VGND.n370 16.0005
R3146 VGND.n367 VGND.n366 16.0005
R3147 VGND.n366 VGND.n363 16.0005
R3148 VGND.n362 VGND.n359 16.0005
R3149 VGND.n359 VGND.n358 16.0005
R3150 VGND.n358 VGND.n355 16.0005
R3151 VGND.n355 VGND.n354 16.0005
R3152 VGND.n354 VGND.n351 16.0005
R3153 VGND.n351 VGND.n350 16.0005
R3154 VGND.n350 VGND.n323 16.0005
R3155 VGND.n399 VGND.n323 16.0005
R3156 VGND.n394 VGND.n381 16.0005
R3157 VGND.n394 VGND.n393 16.0005
R3158 VGND.n393 VGND.n392 16.0005
R3159 VGND.n392 VGND.n389 16.0005
R3160 VGND.n389 VGND.n388 16.0005
R3161 VGND.n388 VGND.n385 16.0005
R3162 VGND.n385 VGND.n384 16.0005
R3163 VGND.n384 VGND.n322 16.0005
R3164 VGND.n837 VGND.n836 16.0005
R3165 VGND.n836 VGND.n833 16.0005
R3166 VGND.n833 VGND.n832 16.0005
R3167 VGND.n832 VGND.n829 16.0005
R3168 VGND.n829 VGND.n828 16.0005
R3169 VGND.n828 VGND.n825 16.0005
R3170 VGND.n825 VGND.n766 16.0005
R3171 VGND.n1249 VGND.n766 16.0005
R3172 VGND.n841 VGND.n840 16.0005
R3173 VGND.n844 VGND.n841 16.0005
R3174 VGND.n845 VGND.n844 16.0005
R3175 VGND.n848 VGND.n845 16.0005
R3176 VGND.n849 VGND.n848 16.0005
R3177 VGND.n853 VGND.n852 16.0005
R3178 VGND.n856 VGND.n853 16.0005
R3179 VGND.n860 VGND.n857 16.0005
R3180 VGND.n861 VGND.n860 16.0005
R3181 VGND.n864 VGND.n861 16.0005
R3182 VGND.n865 VGND.n864 16.0005
R3183 VGND.n868 VGND.n865 16.0005
R3184 VGND.n869 VGND.n868 16.0005
R3185 VGND.n872 VGND.n869 16.0005
R3186 VGND.n1217 VGND.n872 16.0005
R3187 VGND.n1810 VGND.n1796 16.0005
R3188 VGND.n1810 VGND.n1809 16.0005
R3189 VGND.n1809 VGND.n1808 16.0005
R3190 VGND.n1808 VGND.n1805 16.0005
R3191 VGND.n1805 VGND.n1804 16.0005
R3192 VGND.n1804 VGND.n1801 16.0005
R3193 VGND.n1801 VGND.n1800 16.0005
R3194 VGND.n1800 VGND.n1797 16.0005
R3195 VGND.n1795 VGND.n1793 16.0005
R3196 VGND.n1793 VGND.n1790 16.0005
R3197 VGND.n1790 VGND.n1789 16.0005
R3198 VGND.n1789 VGND.n1786 16.0005
R3199 VGND.n1786 VGND.n1785 16.0005
R3200 VGND.n1782 VGND.n1781 16.0005
R3201 VGND.n1781 VGND.n1778 16.0005
R3202 VGND.n1777 VGND.n1774 16.0005
R3203 VGND.n1774 VGND.n1773 16.0005
R3204 VGND.n1773 VGND.n1770 16.0005
R3205 VGND.n1770 VGND.n1769 16.0005
R3206 VGND.n1769 VGND.n1766 16.0005
R3207 VGND.n1766 VGND.n1765 16.0005
R3208 VGND.n1765 VGND.n1762 16.0005
R3209 VGND.n1762 VGND.n1761 16.0005
R3210 VGND.n1621 VGND.n1579 16.0005
R3211 VGND.n1627 VGND.n1579 16.0005
R3212 VGND.n1628 VGND.n1627 16.0005
R3213 VGND.n1629 VGND.n1628 16.0005
R3214 VGND.n1629 VGND.n1577 16.0005
R3215 VGND.n1635 VGND.n1577 16.0005
R3216 VGND.n1636 VGND.n1635 16.0005
R3217 VGND.n1637 VGND.n1636 16.0005
R3218 VGND.n1620 VGND.n1619 16.0005
R3219 VGND.n1619 VGND.n1581 16.0005
R3220 VGND.n1613 VGND.n1581 16.0005
R3221 VGND.n1613 VGND.n1612 16.0005
R3222 VGND.n1612 VGND.n1611 16.0005
R3223 VGND.n1607 VGND.n1606 16.0005
R3224 VGND.n1606 VGND.n1584 16.0005
R3225 VGND.n1601 VGND.n1600 16.0005
R3226 VGND.n1600 VGND.n1599 16.0005
R3227 VGND.n1599 VGND.n1586 16.0005
R3228 VGND.n1594 VGND.n1586 16.0005
R3229 VGND.n1594 VGND.n1593 16.0005
R3230 VGND.n1593 VGND.n1592 16.0005
R3231 VGND.n1592 VGND.n411 16.0005
R3232 VGND.n1677 VGND.n411 16.0005
R3233 VGND.n606 VGND.n605 16.0005
R3234 VGND.n609 VGND.n606 16.0005
R3235 VGND.n610 VGND.n609 16.0005
R3236 VGND.n613 VGND.n610 16.0005
R3237 VGND.n614 VGND.n613 16.0005
R3238 VGND.n617 VGND.n614 16.0005
R3239 VGND.n619 VGND.n617 16.0005
R3240 VGND.n620 VGND.n619 16.0005
R3241 VGND.n602 VGND.n601 16.0005
R3242 VGND.n601 VGND.n598 16.0005
R3243 VGND.n598 VGND.n597 16.0005
R3244 VGND.n597 VGND.n594 16.0005
R3245 VGND.n594 VGND.n593 16.0005
R3246 VGND.n590 VGND.n589 16.0005
R3247 VGND.n589 VGND.n586 16.0005
R3248 VGND.n585 VGND.n582 16.0005
R3249 VGND.n582 VGND.n581 16.0005
R3250 VGND.n581 VGND.n578 16.0005
R3251 VGND.n578 VGND.n577 16.0005
R3252 VGND.n577 VGND.n574 16.0005
R3253 VGND.n574 VGND.n573 16.0005
R3254 VGND.n573 VGND.n570 16.0005
R3255 VGND.n570 VGND.n569 16.0005
R3256 VGND.n1390 VGND.n1348 16.0005
R3257 VGND.n1396 VGND.n1348 16.0005
R3258 VGND.n1397 VGND.n1396 16.0005
R3259 VGND.n1398 VGND.n1397 16.0005
R3260 VGND.n1398 VGND.n1346 16.0005
R3261 VGND.n1404 VGND.n1346 16.0005
R3262 VGND.n1405 VGND.n1404 16.0005
R3263 VGND.n1406 VGND.n1405 16.0005
R3264 VGND.n1389 VGND.n1388 16.0005
R3265 VGND.n1388 VGND.n1350 16.0005
R3266 VGND.n1382 VGND.n1350 16.0005
R3267 VGND.n1382 VGND.n1381 16.0005
R3268 VGND.n1381 VGND.n1380 16.0005
R3269 VGND.n1376 VGND.n1375 16.0005
R3270 VGND.n1375 VGND.n1353 16.0005
R3271 VGND.n1370 VGND.n1369 16.0005
R3272 VGND.n1369 VGND.n1368 16.0005
R3273 VGND.n1368 VGND.n1355 16.0005
R3274 VGND.n1363 VGND.n1355 16.0005
R3275 VGND.n1363 VGND.n1362 16.0005
R3276 VGND.n1362 VGND.n1361 16.0005
R3277 VGND.n1361 VGND.n1332 16.0005
R3278 VGND.n1463 VGND.n1332 16.0005
R3279 VGND.n503 VGND.n502 16.0005
R3280 VGND.n502 VGND.n499 16.0005
R3281 VGND.n499 VGND.n498 16.0005
R3282 VGND.n498 VGND.n495 16.0005
R3283 VGND.n495 VGND.n494 16.0005
R3284 VGND.n494 VGND.n491 16.0005
R3285 VGND.n491 VGND.n490 16.0005
R3286 VGND.n490 VGND.n487 16.0005
R3287 VGND.n507 VGND.n506 16.0005
R3288 VGND.n510 VGND.n507 16.0005
R3289 VGND.n511 VGND.n510 16.0005
R3290 VGND.n514 VGND.n511 16.0005
R3291 VGND.n515 VGND.n514 16.0005
R3292 VGND.n534 VGND.n533 16.0005
R3293 VGND.n533 VGND.n532 16.0005
R3294 VGND.n530 VGND.n527 16.0005
R3295 VGND.n527 VGND.n526 16.0005
R3296 VGND.n526 VGND.n523 16.0005
R3297 VGND.n523 VGND.n522 16.0005
R3298 VGND.n522 VGND.n519 16.0005
R3299 VGND.n519 VGND.n518 16.0005
R3300 VGND.n518 VGND.n469 16.0005
R3301 VGND.n1536 VGND.n469 16.0005
R3302 VGND.n1197 VGND.n1196 16.0005
R3303 VGND.n1200 VGND.n1197 16.0005
R3304 VGND.n1201 VGND.n1200 16.0005
R3305 VGND.n1204 VGND.n1201 16.0005
R3306 VGND.n1205 VGND.n1204 16.0005
R3307 VGND.n1208 VGND.n1205 16.0005
R3308 VGND.n1210 VGND.n1208 16.0005
R3309 VGND.n1211 VGND.n1210 16.0005
R3310 VGND.n1193 VGND.n1192 16.0005
R3311 VGND.n1192 VGND.n1189 16.0005
R3312 VGND.n1189 VGND.n1188 16.0005
R3313 VGND.n1188 VGND.n1185 16.0005
R3314 VGND.n1185 VGND.n1184 16.0005
R3315 VGND.n1181 VGND.n1180 16.0005
R3316 VGND.n1180 VGND.n1177 16.0005
R3317 VGND.n1176 VGND.n1173 16.0005
R3318 VGND.n1173 VGND.n1172 16.0005
R3319 VGND.n1172 VGND.n1169 16.0005
R3320 VGND.n1169 VGND.n1168 16.0005
R3321 VGND.n1168 VGND.n1165 16.0005
R3322 VGND.n1165 VGND.n1164 16.0005
R3323 VGND.n1164 VGND.n1161 16.0005
R3324 VGND.n1161 VGND.n1160 16.0005
R3325 VGND.n1894 VGND.n1893 14.5072
R3326 VGND.n1887 VGND.n187 14.2938
R3327 VGND.n1892 VGND.n1879 13.8672
R3328 VGND.n1217 VGND.n1216 13.6894
R3329 VGND.n1761 VGND.n263 13.6894
R3330 VGND.n1679 VGND.n1677 13.6894
R3331 VGND.n569 VGND.n566 13.6894
R3332 VGND.n1465 VGND.n1463 13.6894
R3333 VGND.n1538 VGND.n1536 13.6894
R3334 VGND.n1160 VGND.n1157 13.6894
R3335 VGND.n1888 VGND.n1886 13.4405
R3336 VGND.n1543 VGND 13.2782
R3337 VGND.n2058 VGND.n62 13.0453
R3338 VGND.n1951 VGND 12.9783
R3339 VGND.n367 VGND 12.9783
R3340 VGND.n852 VGND 12.9783
R3341 VGND.n1782 VGND 12.9783
R3342 VGND.n1607 VGND 12.9783
R3343 VGND.n590 VGND 12.9783
R3344 VGND.n1376 VGND 12.9783
R3345 VGND.n534 VGND 12.9783
R3346 VGND.n1181 VGND 12.9783
R3347 VGND.t19 VGND.n1883 12.6989
R3348 VGND.t13 VGND.n192 12.6989
R3349 VGND.n1529 VGND.n1526 12.6085
R3350 VGND.n1882 VGND.n1881 12.5872
R3351 VGND.n2034 VGND.n69 11.9733
R3352 VGND.n697 VGND 11.889
R3353 VGND.n1909 VGND.n171 11.7338
R3354 VGND.n1297 VGND.n1291 11.6987
R3355 VGND.t17 VGND.n706 11.1397
R3356 VGND.n1249 VGND.n1248 10.3116
R3357 VGND.n1797 VGND.n231 10.3116
R3358 VGND.n1637 VGND.n1575 10.3116
R3359 VGND.n665 VGND.n620 10.3116
R3360 VGND.n1406 VGND.n1324 10.3116
R3361 VGND.n487 VGND.n177 10.3116
R3362 VGND.n1213 VGND.n1211 10.3116
R3363 VGND.n1295 VGND.n1291 10.0194
R3364 VGND.n1297 VGND.n1296 9.88869
R3365 VGND.n1310 VGND 9.76137
R3366 VGND.n1313 VGND 9.60535
R3367 VGND.n1880 VGND.n171 9.4505
R3368 VGND.n1311 VGND.n1310 9.37675
R3369 VGND.n712 VGND.n700 9.32713
R3370 VGND.n1309 VGND.n694 9.3005
R3371 VGND.n1308 VGND.n1307 9.3005
R3372 VGND.n1306 VGND.n695 9.3005
R3373 VGND.n1305 VGND.n1304 9.3005
R3374 VGND.n1303 VGND.n1302 9.3005
R3375 VGND.n1301 VGND.n697 9.3005
R3376 VGND.n1283 VGND.n1282 9.3005
R3377 VGND.n721 VGND.n708 9.3005
R3378 VGND.n720 VGND.n719 9.3005
R3379 VGND.n710 VGND.n709 9.3005
R3380 VGND.n713 VGND.n712 9.3005
R3381 VGND.n1892 VGND.n1891 9.3005
R3382 VGND.n1890 VGND.n187 9.3005
R3383 VGND.n1889 VGND.n1888 9.3005
R3384 VGND.n1882 VGND.n1880 9.3005
R3385 VGND.n1916 VGND.n1915 9.3005
R3386 VGND.n1914 VGND.n1910 9.3005
R3387 VGND.n1316 VGND.n692 9.00464
R3388 VGND.n1299 VGND.n699 8.83503
R3389 VGND.n2011 VGND.n138 8.78595
R3390 VGND.n1300 VGND.n1299 8.77024
R3391 VGND.n2011 VGND.n2010 8.72777
R3392 VGND.t0 VGND.n1541 8.46611
R3393 VGND.n463 VGND.n188 8.33305
R3394 VGND.n1720 VGND.n314 7.8805
R3395 VGND.n801 VGND.n737 7.61523
R3396 VGND.n1754 VGND.n291 7.51963
R3397 VGND.n1301 VGND.n1300 7.11259
R3398 VGND.n1472 VGND.n1471 6.96898
R3399 VGND.n1678 VGND.n406 6.64531
R3400 VGND.n1544 VGND.n1543 6.43248
R3401 VGND.n73 VGND.t29 5.98689
R3402 VGND.n2046 VGND.n75 5.98689
R3403 VGND.n437 VGND.n1 588.939
R3404 VGND.n1497 VGND.n1496 5.92639
R3405 VGND.n1214 VGND.n1156 5.90608
R3406 VGND.n1279 VGND.n692 5.88677
R3407 VGND.n2010 VGND.n139 5.87686
R3408 VGND.n1496 VGND.n1495 5.87686
R3409 VGND.n2005 VGND.n138 5.58595
R3410 VGND.n907 VGND.t31 5.3017
R3411 VGND.n1495 VGND.n165 5.23686
R3412 VGND.n2005 VGND.n2004 5.23686
R3413 VGND.n463 VGND 4.94027
R3414 VGND.n1042 VGND.n957 4.88894
R3415 VGND.n1115 VGND.n897 4.88894
R3416 VGND.n1088 VGND.n920 4.87323
R3417 VGND VGND.n1312 4.47774
R3418 VGND.n1884 VGND.t19 4.2333
R3419 VGND.n794 VGND.n770 4.04261
R3420 VGND.n794 VGND.n793 4.04261
R3421 VGND.n793 VGND.n792 4.04261
R3422 VGND.n786 VGND.n782 4.04261
R3423 VGND.n786 VGND.n785 4.04261
R3424 VGND.n785 VGND.n784 4.04261
R3425 VGND.n784 VGND.n689 4.04261
R3426 VGND.n1322 VGND.n689 4.04261
R3427 VGND.n1323 VGND.n1322 4.04261
R3428 VGND.n213 VGND.n210 4.04261
R3429 VGND.n1572 VGND.n1571 4.04261
R3430 VGND.n2036 VGND.n113 3.98871
R3431 VGND.n624 VGND.n623 3.98871
R3432 VGND.n1482 VGND.n1481 3.98666
R3433 VGND.n1483 VGND.n1482 3.98666
R3434 VGND.n1483 VGND.n678 3.98666
R3435 VGND.n1511 VGND.n679 3.98666
R3436 VGND.n1505 VGND.n679 3.98666
R3437 VGND.n1505 VGND.n1504 3.98666
R3438 VGND.n1504 VGND.n1503 3.98666
R3439 VGND.n1503 VGND.n1489 3.98666
R3440 VGND.n1497 VGND.n1489 3.98666
R3441 VGND.n1271 VGND.n723 3.98666
R3442 VGND.n1271 VGND.n1270 3.98666
R3443 VGND.n1268 VGND.n733 3.98666
R3444 VGND.n1262 VGND.n733 3.97863
R3445 VGND.n800 VGND.n770 3.83497
R3446 VGND.n1078 VGND.n946 3.81507
R3447 VGND.n1079 VGND.n1078 3.81507
R3448 VGND.n1080 VGND.n1079 3.81507
R3449 VGND.n1080 VGND.n921 3.81507
R3450 VGND.n1086 VGND.n922 3.81507
R3451 VGND.n927 VGND.n922 3.81507
R3452 VGND.n938 VGND.n927 3.81507
R3453 VGND.n938 VGND.n937 3.81507
R3454 VGND.n1752 VGND.n292 3.81507
R3455 VGND.n1746 VGND.n292 3.81507
R3456 VGND.n1746 VGND.n1745 3.81507
R3457 VGND.n1745 VGND.n1744 3.81507
R3458 VGND.n1739 VGND.n1738 3.81507
R3459 VGND.n1738 VGND.n1737 3.81507
R3460 VGND.n1737 VGND.n298 3.81507
R3461 VGND.n1731 VGND.n298 3.81507
R3462 VGND.n1731 VGND.n1730 3.81507
R3463 VGND.n1688 VGND.n1687 3.81507
R3464 VGND.n1688 VGND.n404 3.81507
R3465 VGND.n1693 VGND.n404 3.81507
R3466 VGND.n1694 VGND.n1693 3.81507
R3467 VGND.n1699 VGND.n1698 3.81507
R3468 VGND.n1700 VGND.n1699 3.81507
R3469 VGND.n1700 VGND.n400 3.81507
R3470 VGND.n1706 VGND.n400 3.81507
R3471 VGND.n1707 VGND.n1706 3.81507
R3472 VGND.n937 VGND.n936 3.80766
R3473 VGND.n1481 VGND.n684 3.80391
R3474 VGND.n1473 VGND.n1472 3.77815
R3475 VGND.n948 VGND.n920 3.74595
R3476 VGND.n228 VGND.n58 3.65764
R3477 VGND.n987 VGND.n230 3.65764
R3478 VGND.n1753 VGND.n1752 3.6372
R3479 VGND.n1687 VGND.n1686 3.6372
R3480 VGND.n1474 VGND.n1323 3.62257
R3481 VGND.n1067 VGND.n948 3.49141
R3482 VGND.n1730 VGND.n1729 3.36297
R3483 VGND.n1017 VGND.n1016 3.27323
R3484 VGND.n1018 VGND.n1017 3.27323
R3485 VGND.n1018 VGND.n1011 3.27323
R3486 VGND.n1025 VGND.n1011 3.27323
R3487 VGND.n1026 VGND.n1025 3.27323
R3488 VGND.n1027 VGND.n1026 3.27323
R3489 VGND.n1033 VGND.n1008 3.27323
R3490 VGND.n1034 VGND.n1033 3.27323
R3491 VGND.n1036 VGND.n1034 3.27323
R3492 VGND.n1036 VGND.n1035 3.27323
R3493 VGND.n919 VGND.n725 3.27323
R3494 VGND.n1091 VGND.n904 3.27323
R3495 VGND.n1098 VGND.n904 3.27323
R3496 VGND.n1099 VGND.n1098 3.27323
R3497 VGND.n1100 VGND.n1099 3.27323
R3498 VGND.n1106 VGND.n901 3.27323
R3499 VGND.n1107 VGND.n1106 3.27323
R3500 VGND.n1109 VGND.n1107 3.27323
R3501 VGND.n1109 VGND.n1108 3.27323
R3502 VGND.n1048 VGND.n1047 3.27323
R3503 VGND.n1049 VGND.n1048 3.27323
R3504 VGND.n1049 VGND.n953 3.27323
R3505 VGND.n1056 VGND.n953 3.27323
R3506 VGND.n1057 VGND.n1056 3.27323
R3507 VGND.n1058 VGND.n1057 3.27323
R3508 VGND.n1065 VGND.n950 3.27323
R3509 VGND.n1066 VGND.n1065 3.27323
R3510 VGND.n1068 VGND.n1066 3.27323
R3511 VGND.n1068 VGND.n1067 3.27323
R3512 VGND.n1262 VGND.n1261 3.26396
R3513 VGND.n1678 VGND.n303 3.25296
R3514 VGND.n936 VGND.n928 3.14804
R3515 VGND.n1315 VGND.n1314 3.10057
R3516 VGND.n1474 VGND.n1473 3.0813
R3517 VGND.n930 VGND.n291 3.0781
R3518 VGND.n1744 VGND.n296 3.05216
R3519 VGND.n1261 VGND.n1260 3.04639
R3520 VGND.n1948 VGND 3.02272
R3521 VGND.n370 VGND 3.02272
R3522 VGND.n849 VGND 3.02272
R3523 VGND.n1785 VGND 3.02272
R3524 VGND.n1611 VGND 3.02272
R3525 VGND.n593 VGND 3.02272
R3526 VGND.n1380 VGND 3.02272
R3527 VGND VGND.n515 3.02272
R3528 VGND.n1184 VGND 3.02272
R3529 VGND.n1260 VGND.n737 3.01013
R3530 VGND.n2 VGND.t29 1.00003
R3531 VGND.n930 VGND.n928 2.9382
R3532 VGND.n1729 VGND.n303 2.9382
R3533 VGND VGND.n1008 2.90959
R3534 VGND VGND.n901 2.90959
R3535 VGND VGND.n950 2.90959
R3536 VGND.n1995 VGND.n165 2.90959
R3537 VGND.n1994 VGND.n166 2.90959
R3538 VGND.n1990 VGND.n1989 2.90959
R3539 VGND.n1986 VGND.n170 2.90959
R3540 VGND.n1978 VGND.n1919 2.90959
R3541 VGND.n1980 VGND.n1979 2.90959
R3542 VGND.n2000 VGND.n144 2.90959
R3543 VGND.n2001 VGND.n142 2.90959
R3544 VGND.n1312 VGND.n692 2.89965
R3545 VGND.n1042 VGND.n959 2.89497
R3546 VGND.n968 VGND.n959 2.89497
R3547 VGND.n1001 VGND.n968 2.89497
R3548 VGND.n1001 VGND.n1000 2.89497
R3549 VGND.n1000 VGND.n999 2.89497
R3550 VGND.n999 VGND.n996 2.89497
R3551 VGND.n996 VGND.n995 2.89497
R3552 VGND.n995 VGND.n992 2.89497
R3553 VGND.n992 VGND.n991 2.89497
R3554 VGND.n991 VGND.n988 2.89497
R3555 VGND.n1115 VGND.n894 2.89497
R3556 VGND.n1122 VGND.n894 2.89497
R3557 VGND.n1122 VGND.n890 2.89497
R3558 VGND.n1128 VGND.n890 2.89497
R3559 VGND.n1129 VGND.n1128 2.89497
R3560 VGND.n1129 VGND.n887 2.89497
R3561 VGND.n887 VGND.n885 2.89497
R3562 VGND.n1137 VGND.n885 2.89497
R3563 VGND.n1137 VGND.n881 2.89497
R3564 VGND.n1143 VGND.n881 2.89497
R3565 VGND.n1570 VGND.n436 2.89497
R3566 VGND.n438 VGND.n436 2.89497
R3567 VGND.n1563 VGND.n438 2.89497
R3568 VGND.n1563 VGND.n1562 2.89497
R3569 VGND.n1562 VGND.n1561 2.89497
R3570 VGND.n1561 VGND.n316 2.89497
R3571 VGND.n1715 VGND.n316 2.89497
R3572 VGND.n1715 VGND.n1714 2.89497
R3573 VGND.n1714 VGND.n1713 2.89497
R3574 VGND.n1713 VGND.n1709 2.89497
R3575 VGND.n2029 VGND.n116 2.89497
R3576 VGND.n2029 VGND.n2028 2.89497
R3577 VGND.n2028 VGND.n2027 2.89497
R3578 VGND.n2027 VGND.n122 2.89497
R3579 VGND.n2021 VGND.n122 2.89497
R3580 VGND.n2021 VGND.n2020 2.89497
R3581 VGND.n2020 VGND.n2019 2.89497
R3582 VGND.n2019 VGND.n130 2.89497
R3583 VGND.n2013 VGND.n130 2.89497
R3584 VGND.n2013 VGND.n2012 2.89497
R3585 VGND.n1144 VGND.n1143 2.89028
R3586 VGND.n1834 VGND.n1833 2.8805
R3587 VGND.n1837 VGND.n1834 2.8805
R3588 VGND.n1837 VGND.n225 2.8805
R3589 VGND.n1845 VGND.n225 2.8805
R3590 VGND.n1846 VGND.n1845 2.8805
R3591 VGND.n1849 VGND.n1846 2.8805
R3592 VGND.n1849 VGND.n223 2.8805
R3593 VGND.n1855 VGND.n223 2.8805
R3594 VGND.n1855 VGND.n212 2.8805
R3595 VGND.n1861 VGND.n212 2.8805
R3596 VGND.n1512 VGND.n1511 2.87939
R3597 VGND.n988 VGND.n987 2.86281
R3598 VGND.n946 VGND.n920 2.79785
R3599 VGND.n1881 VGND.n171 2.77383
R3600 VGND.n782 VGND.n777 2.74015
R3601 VGND.n1574 VGND.n1572 2.72218
R3602 VGND.n627 VGND.n622 2.66829
R3603 VGND.n1904 VGND.n1903 2.6561
R3604 VGND.n1900 VGND.n178 2.6561
R3605 VGND.n1899 VGND.n181 2.6561
R3606 VGND.n1518 VGND.n1515 2.6561
R3607 VGND.n1521 VGND.n1519 2.6561
R3608 VGND.n1523 VGND.n1522 2.6561
R3609 VGND.n1531 VGND.n537 2.6561
R3610 VGND.n1538 VGND.n1537 2.64015
R3611 VGND.n1694 VGND.n402 2.62831
R3612 VGND.n1277 VGND.n725 2.62326
R3613 VGND.n177 VGND.n139 2.61072
R3614 VGND.n2051 VGND.n67 2.5605
R3615 VGND.n2050 VGND.n71 2.5605
R3616 VGND.n89 VGND.n88 2.5605
R3617 VGND.n93 VGND.n92 2.5605
R3618 VGND.n98 VGND.n85 2.5605
R3619 VGND.n99 VGND.n84 2.5605
R3620 VGND.n104 VGND.n102 2.5605
R3621 VGND.n103 VGND.n81 2.5605
R3622 VGND.n2043 VGND.n2042 2.5605
R3623 VGND.n108 VGND.n82 2.5605
R3624 VGND.n1867 VGND.n1866 2.53355
R3625 VGND.n1269 VGND.n1268 2.52507
R3626 VGND.n2037 VGND.n110 2.47966
R3627 VGND.n1144 VGND.n877 2.4726
R3628 VGND.n538 VGND.n468 2.47154
R3629 VGND.n1315 VGND.n1311 2.46988
R3630 VGND.n1829 VGND.n230 2.46298
R3631 VGND.n2056 VGND.n2055 2.45173
R3632 VGND.n1087 VGND.n921 2.41639
R3633 VGND.n1995 VGND.n1994 2.32777
R3634 VGND.n1990 VGND.n166 2.32777
R3635 VGND.n1989 VGND.n170 2.32777
R3636 VGND.n1986 VGND.n1985 2.32777
R3637 VGND.n1975 VGND.n1919 2.32777
R3638 VGND.n1980 VGND.n1978 2.32777
R3639 VGND.n1979 VGND.n144 2.32777
R3640 VGND.n2001 VGND.n2000 2.32777
R3641 VGND.n2004 VGND.n142 2.32777
R3642 VGND.n1153 VGND.n877 2.3078
R3643 VGND.n2061 VGND.n2060 2.29231
R3644 VGND.n1215 VGND.n1153 2.28033
R3645 VGND.n1314 VGND.n1312 2.27956
R3646 VGND.n1904 VGND.n177 2.23121
R3647 VGND.n1091 VGND.n1090 2.14595
R3648 VGND.n1903 VGND.n178 2.12498
R3649 VGND.n1900 VGND.n1899 2.12498
R3650 VGND.n1519 VGND.n1518 2.12498
R3651 VGND.n1523 VGND.n1521 2.12498
R3652 VGND.n1522 VGND.n537 2.12498
R3653 VGND.n1571 VGND.n1570 2.12311
R3654 VGND.n623 VGND.n116 2.12311
R3655 VGND.n1833 VGND.n228 2.1125
R3656 VGND.n540 VGND.n539 2.07618
R3657 VGND.n1531 VGND.n1530 2.01794
R3658 VGND.n1314 VGND.n1313 2.01138
R3659 VGND.n1537 VGND.n311 1.99042
R3660 VGND.n539 VGND.n538 1.97733
R3661 VGND.n1539 VGND.n468 1.97733
R3662 VGND.n1043 VGND.n958 1.951
R3663 VGND.n1831 VGND.n64 1.951
R3664 VGND.n434 VGND.n217 1.951
R3665 VGND.n2057 VGND.n65 1.951
R3666 VGND.n1116 VGND.n895 1.951
R3667 VGND.n915 VGND.n724 1.951
R3668 VGND.n799 VGND.n769 1.951
R3669 VGND.n1477 VGND.n685 1.951
R3670 VGND.n621 VGND.n118 1.951
R3671 VGND.n1886 VGND.n1882 1.9205
R3672 VGND.n1016 VGND.n897 1.89141
R3673 VGND.n1047 VGND.n957 1.89141
R3674 VGND.n1539 VGND.n1538 1.87849
R3675 VGND.n1917 VGND.n1916 1.75952
R3676 VGND.n1035 VGND.n957 1.74595
R3677 VGND.n1108 VGND.n897 1.74595
R3678 VGND.n711 VGND.n700 1.66677
R3679 VGND.n1284 VGND.n1283 1.66677
R3680 VGND.n1280 VGND.n722 1.63495
R3681 VGND.n1913 VGND.n1912 1.55639
R3682 VGND.n1293 VGND.n1292 1.55639
R3683 VGND.n1514 VGND.n181 1.54075
R3684 VGND VGND.n1281 1.52759
R3685 VGND.n714 VGND.n713 1.51529
R3686 VGND.n718 VGND.n708 1.51529
R3687 VGND.n1270 VGND.n1269 1.46209
R3688 VGND.n1514 VGND.n1513 1.45707
R3689 VGND.n1278 VGND.n1277 1.4194
R3690 VGND.n1087 VGND.n1086 1.39918
R3691 VGND.n1985 VGND.n1917 1.39686
R3692 VGND.n717 VGND.n710 1.36381
R3693 VGND.n719 VGND.n717 1.36381
R3694 VGND.n566 VGND.n209 1.32468
R3695 VGND.n1465 VGND.n1464 1.3077
R3696 VGND.n792 VGND.n777 1.30296
R3697 VGND.n1644 VGND.n1643 1.24081
R3698 VGND.n431 VGND.n428 1.24081
R3699 VGND.n1650 VGND.n429 1.24081
R3700 VGND.n1657 VGND.n420 1.24081
R3701 VGND.n1656 VGND.n418 1.24081
R3702 VGND.n1665 VGND.n1664 1.24081
R3703 VGND.n1672 VGND.n414 1.24081
R3704 VGND.n1671 VGND.n410 1.24081
R3705 VGND.n0 VGND.t36 1.2329
R3706 VGND.t16 VGND.n704 1.23819
R3707 VGND.n768 VGND.n767 1.21723
R3708 VGND.n1255 VGND.n1254 1.21723
R3709 VGND.n807 VGND.n806 1.21723
R3710 VGND.n1235 VGND.n811 1.21723
R3711 VGND.n1238 VGND.n1234 1.21723
R3712 VGND.n820 VGND.n816 1.21723
R3713 VGND.n1221 VGND.n823 1.21723
R3714 VGND.n1224 VGND.n1220 1.21723
R3715 VGND.n1575 VGND.n1574 1.21689
R3716 VGND.n714 VGND.n710 1.21233
R3717 VGND.n719 VGND.n718 1.21233
R3718 VGND.n1157 VGND.n57 1.20153
R3719 VGND.n1825 VGND.n1824 1.19453
R3720 VGND.n1821 VGND.n234 1.19453
R3721 VGND.n1820 VGND.n239 1.19453
R3722 VGND.n1816 VGND.n1815 1.19453
R3723 VGND.n272 VGND.n244 1.19453
R3724 VGND.n279 VGND.n267 1.19453
R3725 VGND.n287 VGND.n286 1.19453
R3726 VGND.n1758 VGND.n264 1.19453
R3727 VGND.n2087 VGND.n25 1.19453
R3728 VGND.n30 VGND.n26 1.19453
R3729 VGND.n2081 VGND.n31 1.19453
R3730 VGND.n38 VGND.n33 1.19453
R3731 VGND.n2076 VGND.n2075 1.19453
R3732 VGND.n49 VGND.n48 1.19453
R3733 VGND.n51 VGND.n45 1.19453
R3734 VGND.n2066 VGND.n46 1.19453
R3735 VGND.n670 VGND.n564 1.1912
R3736 VGND.n651 VGND.n565 1.1912
R3737 VGND.n657 VGND.n656 1.1912
R3738 VGND.n647 VGND.n646 1.1912
R3739 VGND.n637 VGND.n631 1.1912
R3740 VGND.n634 VGND.n202 1.1912
R3741 VGND.n1872 VGND.n203 1.1912
R3742 VGND.n1698 VGND.n402 1.18726
R3743 VGND.n665 VGND.n664 1.163
R3744 VGND.n1829 VGND.n231 1.15277
R3745 VGND.n1090 VGND.n919 1.12777
R3746 VGND.n1449 VGND.n1448 1.11989
R3747 VGND.n1445 VGND.n1410 1.11989
R3748 VGND.n1414 VGND.n1413 1.11989
R3749 VGND.n1440 VGND.n1415 1.11989
R3750 VGND.n1437 VGND.n1436 1.11989
R3751 VGND.n1425 VGND.n1424 1.11989
R3752 VGND.n1458 VGND.n1337 1.11989
R3753 VGND.n1338 VGND.n1334 1.11989
R3754 VGND.n1512 VGND.n678 1.10777
R3755 VGND.n1974 VGND.n1917 1.10595
R3756 VGND.n677 VGND.n676 1.09548
R3757 VGND.n775 VGND.n774 1.07944
R3758 VGND.n1231 VGND 1.07122
R3759 VGND.n1888 VGND.n1887 1.06717
R3760 VGND.n713 VGND.n711 1.06085
R3761 VGND.n1284 VGND.n708 1.06085
R3762 VGND.n1644 VGND.n1575 1.04236
R3763 VGND.n666 VGND.n665 1.04236
R3764 VGND.n1450 VGND.n1324 1.02255
R3765 VGND.n1825 VGND.n231 1.00349
R3766 VGND VGND.n2092 1.00349
R3767 VGND.n1643 VGND.n431 0.992748
R3768 VGND.n1650 VGND.n428 0.992748
R3769 VGND.n429 VGND.n420 0.992748
R3770 VGND.n1657 VGND.n1656 0.992748
R3771 VGND.n421 VGND.n418 0.992748
R3772 VGND.n1663 VGND 0.992748
R3773 VGND.n1665 VGND.n1663 0.992748
R3774 VGND.n1664 VGND.n414 0.992748
R3775 VGND.n1672 VGND.n1671 0.992748
R3776 VGND.n1680 VGND.n410 0.992748
R3777 VGND.n670 VGND.n669 0.992748
R3778 VGND.n652 VGND.n651 0.992748
R3779 VGND.n656 VGND.n655 0.992748
R3780 VGND.n675 VGND.n543 0.992748
R3781 VGND.n646 VGND.n645 0.992748
R3782 VGND.n641 VGND.n639 0.992748
R3783 VGND.n633 VGND.n631 0.992748
R3784 VGND.n1873 VGND.n202 0.992748
R3785 VGND.n205 VGND.n203 0.992748
R3786 VGND.n1448 VGND.n1344 0.973884
R3787 VGND.n1445 VGND.n1444 0.973884
R3788 VGND.n1441 VGND.n1414 0.973884
R3789 VGND.n1416 VGND.n1415 0.973884
R3790 VGND.n1436 VGND.n1419 0.973884
R3791 VGND.n1430 VGND.n1429 0.973884
R3792 VGND.n1426 VGND.n1425 0.973884
R3793 VGND.n1458 VGND.n1457 0.973884
R3794 VGND.n1334 VGND.n1331 0.973884
R3795 VGND.n1824 VGND.n234 0.955724
R3796 VGND.n1821 VGND.n1820 0.955724
R3797 VGND.n1816 VGND.n239 0.955724
R3798 VGND.n1815 VGND.n244 0.955724
R3799 VGND.n276 VGND.n272 0.955724
R3800 VGND VGND.n270 0.955724
R3801 VGND.n279 VGND.n270 0.955724
R3802 VGND.n287 VGND.n267 0.955724
R3803 VGND.n286 VGND.n264 0.955724
R3804 VGND.n1758 VGND.n1757 0.955724
R3805 VGND.n1213 VGND.n1212 0.955724
R3806 VGND.n1680 VGND.n1679 0.943136
R3807 VGND VGND.n641 0.943136
R3808 VGND.n1861 VGND.n213 0.9285
R3809 VGND.n113 VGND.n112 0.9285
R3810 VGND.n1248 VGND.n1247 0.925215
R3811 VGND.n1216 VGND.n874 0.925215
R3812 VGND.n1290 VGND.n700 0.909376
R3813 VGND.n1283 VGND.n699 0.909376
R3814 VGND.n1757 VGND.n263 0.907963
R3815 VGND.n2087 VGND.n2086 0.907963
R3816 VGND.n2082 VGND.n30 0.907963
R3817 VGND.n39 VGND.n38 0.907963
R3818 VGND.n2075 VGND.n2074 0.907963
R3819 VGND.n2092 VGND.n4 0.907963
R3820 VGND.n48 VGND.n42 0.907963
R3821 VGND.n2067 VGND.n45 0.907963
R3822 VGND.n54 VGND.n46 0.907963
R3823 VGND.n1157 VGND.n55 0.907963
R3824 VGND.n1679 VGND.n1678 0.893523
R3825 VGND.n566 VGND.n206 0.893523
R3826 VGND.n1248 VGND.n737 0.876546
R3827 VGND.n767 VGND.n745 0.876546
R3828 VGND.n1254 VGND.n746 0.876546
R3829 VGND.n808 VGND.n807 0.876546
R3830 VGND.n1239 VGND.n811 0.876546
R3831 VGND.n1234 VGND.n812 0.876546
R3832 VGND.n1231 VGND.n1230 0.876546
R3833 VGND.n820 VGND.n818 0.876546
R3834 VGND.n1225 VGND.n823 0.876546
R3835 VGND.n1220 VGND.n824 0.876546
R3836 VGND.n1216 VGND.n1215 0.876546
R3837 VGND.n1472 VGND.n1324 0.876546
R3838 VGND.n1430 VGND 0.876546
R3839 VGND.n291 VGND.n263 0.860201
R3840 VGND.n1214 VGND.n1213 0.860201
R3841 VGND.n1471 VGND.n684 0.844053
R3842 VGND.n801 VGND.n800 0.834494
R3843 VGND.n1466 VGND.n1465 0.827876
R3844 VGND.n1302 VGND.n1301 0.816075
R3845 VGND.n1306 VGND.n1305 0.816075
R3846 VGND.n1307 VGND.n1306 0.816075
R3847 VGND.n1307 VGND.n694 0.816075
R3848 VGND.n1311 VGND.n694 0.816075
R3849 VGND.n1754 VGND.n1753 0.804872
R3850 VGND.n1686 VGND.n406 0.804872
R3851 VGND.n1739 VGND.n296 0.763414
R3852 VGND.n1305 VGND.n696 0.725456
R3853 VGND.n1296 VGND 0.710768
R3854 VGND.n774 VGND.n31 0.693037
R3855 VGND.n1915 VGND 0.683714
R3856 VGND.n1281 VGND 0.678768
R3857 VGND.n1893 VGND.n1892 0.6405
R3858 VGND.n676 VGND.n542 0.620655
R3859 VGND.n1515 VGND.n1514 0.584732
R3860 VGND.n676 VGND.n675 0.571043
R3861 VGND.n1916 VGND.n1910 0.565899
R3862 VGND.n1269 VGND.n722 0.517167
R3863 VGND.n1278 VGND.n723 0.487697
R3864 VGND.n1722 VGND.n310 0.469573
R3865 VGND.n776 VGND.n775 0.434711
R3866 VGND.n1513 VGND.n677 0.418921
R3867 VGND.n1975 VGND.n1974 0.407773
R3868 VGND.n1530 VGND.n540 0.395867
R3869 VGND.n776 VGND.n677 0.382079
R3870 VGND.n1708 VGND.n1707 0.381957
R3871 VGND.n1293 VGND 0.377286
R3872 VGND.n1027 VGND 0.364136
R3873 VGND.n1100 VGND 0.364136
R3874 VGND.n1058 VGND 0.364136
R3875 VGND.n1156 VGND.n66 0.357582
R3876 VGND.n1544 VGND.n311 0.327429
R3877 VGND.n1911 VGND 0.321929
R3878 VGND.n2055 VGND.n67 0.3205
R3879 VGND.n2051 VGND.n2050 0.3205
R3880 VGND.n88 VGND.n71 0.3205
R3881 VGND.n92 VGND.n89 0.3205
R3882 VGND.n93 VGND.n85 0.3205
R3883 VGND.n99 VGND.n98 0.3205
R3884 VGND.n102 VGND.n84 0.3205
R3885 VGND.n104 VGND.n103 0.3205
R3886 VGND.n2043 VGND.n81 0.3205
R3887 VGND.n2042 VGND.n82 0.3205
R3888 VGND.n112 VGND.n108 0.3205
R3889 VGND.n1709 VGND.n1708 0.289947
R3890 VGND.n2012 VGND.n2011 0.289947
R3891 VGND.n2056 VGND.n66 0.275178
R3892 VGND.n1722 VGND.n311 0.270572
R3893 VGND.n421 VGND 0.248562
R3894 VGND.n642 VGND 0.248562
R3895 VGND.n1513 VGND.n1512 0.245237
R3896 VGND.n1421 VGND 0.243846
R3897 VGND.n276 VGND 0.239306
R3898 VGND.n777 VGND.n776 0.233
R3899 VGND.n774 VGND.n773 0.215425
R3900 VGND.n1894 VGND.n187 0.213833
R3901 VGND VGND.n3 0.191545
R3902 VGND.n1891 VGND 0.179667
R3903 VGND.n1889 VGND.n1880 0.1505
R3904 VGND.n1890 VGND.n1889 0.1505
R3905 VGND.n1891 VGND.n1890 0.1505
R3906 VGND.n813 VGND 0.146508
R3907 VGND.n1215 VGND.n1214 0.137839
R3908 VGND.n775 VGND.n722 0.129447
R3909 VGND.n1294 VGND 0.110917
R3910 VGND.n1464 VGND.n110 0.108289
R3911 VGND.n2037 VGND.n2036 0.108289
R3912 VGND.n1708 VGND.n310 0.107107
R3913 VGND VGND.n463 0.100892
R3914 VGND.n1247 VGND.n768 0.0978384
R3915 VGND.n1255 VGND.n745 0.0978384
R3916 VGND.n806 VGND.n746 0.0978384
R3917 VGND.n1235 VGND.n808 0.0978384
R3918 VGND.n1239 VGND.n1238 0.0978384
R3919 VGND.n813 VGND.n812 0.0978384
R3920 VGND.n1230 VGND.n816 0.0978384
R3921 VGND.n1221 VGND.n818 0.0978384
R3922 VGND.n1225 VGND.n1224 0.0978384
R3923 VGND.n874 VGND.n824 0.0978384
R3924 VGND.n1450 VGND.n1449 0.0978384
R3925 VGND.n1410 VGND.n1344 0.0978384
R3926 VGND.n1444 VGND.n1413 0.0978384
R3927 VGND.n1441 VGND.n1440 0.0978384
R3928 VGND.n1437 VGND.n1416 0.0978384
R3929 VGND.n1421 VGND.n1419 0.0978384
R3930 VGND.n1429 VGND.n1424 0.0978384
R3931 VGND.n1426 VGND.n1337 0.0978384
R3932 VGND.n1457 VGND.n1338 0.0978384
R3933 VGND.n1466 VGND.n1331 0.0978384
R3934 VGND.n1302 VGND.n696 0.0911195
R3935 VGND.n1303 VGND.n697 0.0905
R3936 VGND.n1304 VGND.n1303 0.0905
R3937 VGND.n1304 VGND.n695 0.0905
R3938 VGND.n1308 VGND.n695 0.0905
R3939 VGND.n1309 VGND.n1308 0.0905
R3940 VGND.n623 VGND.n113 0.0813421
R3941 VGND.n1911 VGND 0.0755
R3942 VGND.n1867 VGND.n209 0.0543947
R3943 VGND.n1866 VGND.n210 0.0543947
R3944 VGND.n624 VGND.n622 0.0543947
R3945 VGND.n664 VGND.n627 0.0543947
R3946 VGND.n666 VGND.n564 0.0501124
R3947 VGND.n669 VGND.n565 0.0501124
R3948 VGND.n657 VGND.n652 0.0501124
R3949 VGND.n655 VGND.n542 0.0501124
R3950 VGND.n647 VGND.n543 0.0501124
R3951 VGND.n645 VGND.n642 0.0501124
R3952 VGND.n639 VGND.n637 0.0501124
R3953 VGND.n634 VGND.n633 0.0501124
R3954 VGND.n1873 VGND.n1872 0.0501124
R3955 VGND.n206 VGND.n205 0.0501124
R3956 VGND.n2061 VGND.n57 0.0492619
R3957 VGND.n2060 VGND.n58 0.0492619
R3958 VGND.n1212 VGND.n25 0.0482612
R3959 VGND.n2086 VGND.n26 0.0482612
R3960 VGND.n2082 VGND.n2081 0.0482612
R3961 VGND.n773 VGND.n33 0.0482612
R3962 VGND.n2076 VGND.n39 0.0482612
R3963 VGND.n2074 VGND.n3 0.0482612
R3964 VGND.n49 VGND.n4 0.0482612
R3965 VGND.n51 VGND.n42 0.0482612
R3966 VGND.n2067 VGND.n2066 0.0482612
R3967 VGND.n55 VGND.n54 0.0482612
R3968 VGND.n1281 VGND.n1280 0.04675
R3969 VGND.n1280 VGND.n1279 0.0465396
R3970 VGND.n1296 VGND.n1295 0.038
R3971 VGND.n1915 VGND.n1914 0.0305
R3972 VGND.n1571 VGND.n213 0.0274474
R3973 VGND.n712 VGND.n709 0.0271272
R3974 VGND.n720 VGND.n709 0.0271272
R3975 VGND.n721 VGND.n720 0.0271272
R3976 VGND.n1282 VGND.n721 0.0271272
R3977 VGND.n987 VGND.n228 0.024881
R3978 VGND.n1295 VGND.n1294 0.0234167
R3979 VGND.n1313 VGND 0.0232273
R3980 VGND.n1914 VGND.n1913 0.01425
R3981 VGND.n1310 VGND.n1309 0.01425
R3982 VGND.n1282 VGND 0.0134438
R3983 VGND.n1913 VGND.n1911 0.0134167
R3984 VGND.n1294 VGND.n1293 0.00228571
C0 inv_0.Y M1.S1 0.1038f
C1 MSU1.S VDPWR 0.85466f
C2 ui_in[0] VDPWR 1.78007f
C3 RPTAT_lay_0.B Q1.Emitter 1.72159f
C4 M1.G0 VDPWR 31.7418f
C5 M1.S1 Q1.Emitter 5.38192f
C6 RPTAT_lay_0.B M1.S1 0.20207f
C7 Q1.Emitter RCTAT_lay_0.A 0.36175f
C8 RPTAT_lay_0.B RCTAT_lay_0.A 0.78797f
C9 M1.S1 RCTAT_lay_0.A 4.21255f
C10 inv_0.Y ui_in[0] 0.49386f
C11 RCTAT_lay_0.sky130_fd_pr__res_xhigh_po_0p35_7LQ4N7_2.R1 RCTAT_lay_0.sky130_fd_pr__res_xhigh_po_0p35_7LQ4N7_4.R1 0.47166f
C12 MSU1.S ME1.S 0.43673f
C13 ME1.S ui_in[0] 0.85796f
C14 ME1.S M1.G0 0.47873f
C15 ui_in[0] ua[0] 0.11988f
C16 MSU1.S M1.S1 0.28923f
C17 M1.S1 ui_in[0] 1.08519f
C18 M1.G0 ua[0] 4.40953f
C19 RCTAT_lay_0.sky130_fd_pr__res_xhigh_po_0p35_7LQ4N7_3.R2 RCTAT_lay_0.sky130_fd_pr__res_xhigh_po_0p35_7LQ4N7_5.R2 0.47166f
C20 inv_0.Y VDPWR 0.61381f
C21 M1.G0 M1.S1 8.99414f
C22 M1.G0 RCTAT_lay_0.A 2.23607f
C23 RL_lay_0.R3.R1 ua[0] 0.60709f
C24 ME1.S VDPWR 1.8469f
C25 VDPWR ua[0] 2.54585f
C26 M1.S1 VDPWR 2.5638f
C27 RL_lay_0.sky130_fd_pr__res_xhigh_po_0p35_RTNBCE_0.R2 ui_in[0] 0.1487f
C28 ME2.S M1.S1 0.11748f
C29 MSU1.S ui_in[0] 0.10572f
C30 MSU1.S M1.G0 0.17513f
C31 RL_lay_0.R4.R2 RL_lay_0.sky130_fd_pr__res_xhigh_po_0p35_RTNBCE_0.R2 0.46096f
C32 RCTAT_lay_0.sky130_fd_pr__res_xhigh_po_0p35_7LQ4N7_1.R2 RCTAT_lay_0.sky130_fd_pr__res_xhigh_po_0p35_7LQ4N7_3.R2 0.47166f
C33 M1.G0 ui_in[0] 0.26703f
C34 RCTAT_lay_0.sky130_fd_pr__res_xhigh_po_0p35_7LQ4N7_2.R1 RCTAT_lay_0.A 0.56366f
C35 RL_lay_0.R4.R2 ui_in[0] 0.1537f
C36 ui_in[0] VGND 5.53031f
C37 ua[0] VGND 2.62171f
C38 VDPWR VGND 63.41115f
C39 RCTAT_lay_0.sky130_fd_pr__res_xhigh_po_0p35_7LQ4N7_5.R2 VGND 0.5591f
C40 RCTAT_lay_0.sky130_fd_pr__res_xhigh_po_0p35_7LQ4N7_4.R1 VGND 0.78364f
C41 RCTAT_lay_0.sky130_fd_pr__res_xhigh_po_0p35_7LQ4N7_3.R2 VGND 0.31907f
C42 RCTAT_lay_0.sky130_fd_pr__res_xhigh_po_0p35_7LQ4N7_2.R1 VGND 0.31184f
C43 RCTAT_lay_0.sky130_fd_pr__res_xhigh_po_0p35_7LQ4N7_1.R2 VGND 0.54568f
C44 RL_lay_0.R4.R2 VGND 0.57236f
C45 RL_lay_0.R3.R1 VGND 0.74223f
C46 RL_lay_0.sky130_fd_pr__res_xhigh_po_0p35_RTNBCE_0.R2 VGND 0.56647f
C47 RPTAT_lay_0.B VGND 15.3048f
C48 ME2.S VGND 0.26468f
C49 MSU1.S VGND 0.27493f
C50 ME1.S VGND 0.4006f
C51 inv_0.Y VGND 0.89612f
C52 RCTAT_lay_0.A VGND 8.83973f
C53 Q1.Emitter VGND 5.43069f
C54 M1.S1 VGND 17.5998f
C55 M1.G0 VGND 3.73367f
C56 VDPWR.n99 VGND 0.18823f
C57 VDPWR.n100 VGND 0.61539f
C58 VDPWR.n101 VGND 0.47166f
C59 VDPWR.n102 VGND 0.40375f
C60 VDPWR.n103 VGND 0.28755f
C61 VDPWR.n104 VGND 0.35465f
C62 VDPWR.n105 VGND 3.74217f
C63 VDPWR.n106 VGND 1.86952f
C64 VDPWR.n107 VGND 0.63031f
C65 VDPWR.t34 VGND 1.25395f
C66 VDPWR.t32 VGND 0.95807f
C67 VDPWR.t37 VGND 0.7529f
C68 VDPWR.t30 VGND 0.78608f
C69 VDPWR.t36 VGND 0.7529f
C70 VDPWR.t28 VGND 0.44282f
C71 VDPWR.n108 VGND 0.29063f
C72 VDPWR.t43 VGND 0.71858f
C73 VDPWR.t26 VGND 0.54134f
C74 VDPWR.t41 VGND 0.59856f
C75 VDPWR.t39 VGND 0.62932f
C76 VDPWR.t24 VGND -0.10014f
C77 VDPWR.n110 VGND 0.20487f
C78 VDPWR.n112 VGND 0.23348f
C79 VDPWR.n129 VGND 0.28056f
C80 VDPWR.n143 VGND 0.16829f
C81 VDPWR.n145 VGND 0.28421f
C82 VDPWR.n146 VGND 0.88199f
C83 VDPWR.t22 VGND 1.12243f
C84 VDPWR.t20 VGND 1.03255f
C85 VDPWR.t18 VGND 0.77284f
C86 VDPWR.t0 VGND 1.29461f
C87 VDPWR.t2 VGND 1.03255f
C88 VDPWR.t4 VGND 1.03255f
C89 VDPWR.t6 VGND 1.03255f
C90 VDPWR.t8 VGND 1.03255f
C91 VDPWR.t10 VGND 1.23812f
C92 VDPWR.t12 VGND 1.23812f
C93 VDPWR.t14 VGND 1.03255f
C94 VDPWR.t16 VGND 0.77598f
C95 VDPWR.n147 VGND 0.51628f
C96 VDPWR.n148 VGND 0.81103f
C97 VDPWR.n149 VGND 2.83527f
C98 VDPWR.n150 VGND 0.11356f
C99 VDPWR.n151 VGND 0.35637f
C100 VDPWR.n152 VGND 0.40126f
C101 VDPWR.n153 VGND 0.28927f
C102 VDPWR.n154 VGND 0.47166f
C103 VDPWR.n155 VGND 0.88385f
C104 ua[0].n7 VGND 0.18864f
C105 ua[0].n15 VGND 0.25295f
C106 ua[0].n16 VGND 0.20395f
C107 ua[0].n18 VGND 0.12289f
C108 ua[0].n20 VGND 1.02897f
C109 ua[0].n21 VGND 0.21785f
C110 ua[0].n22 VGND 0.12926f
C111 ua[0].n29 VGND 0.13075f
C112 ua[0].n33 VGND 0.15177f
C113 ua[0].n38 VGND 0.13676f
C114 ua[0].n44 VGND 0.40124f
C115 ua[0].n45 VGND 0.28705f
C116 ua[0].n46 VGND 0.13766f
C117 ua[0].n50 VGND 0.41698f
C118 ua[0].n56 VGND 0.40981f
C119 ua[0].n57 VGND 0.55193f
C120 ua[0].n58 VGND 0.18194f
C121 ua[0].n60 VGND 0.13694f
C122 ui_in[0].n2 VGND 0.44167f
C123 ui_in[0].t4 VGND 0.19054f
C124 ui_in[0].n3 VGND 0.14929f
C125 ui_in[0].n4 VGND 1.31594f
C126 ui_in[0].n5 VGND 0.11939f
C127 ui_in[0].t3 VGND 0.26742f
C128 ui_in[0].n8 VGND 0.18864f
C129 ui_in[0].t2 VGND 0.26742f
.ends
