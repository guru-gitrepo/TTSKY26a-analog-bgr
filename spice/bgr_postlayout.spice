* NGSPICE file created from bgr_core.ext - technology: sky130A

.subckt bgr_core VDPWR VGND ua[0] ui_in[0]
X0 RL_lay_0.R3.R1 RL_lay_0.R4.R2 VGND.t21 sky130_fd_pr__res_xhigh_po_0p35 l=4.18
X1 VDPWR.t11 M1.G0 M1.S1 VDPWR.t10 sky130_fd_pr__pfet_01v8_lvt ad=1.45 pd=10.58 as=0.725 ps=5.29 w=5 l=3
X2 M1.G0 M1.S1 RCTAT_lay_0.A VGND.t11 sky130_fd_pr__nfet_01v8_lvt ad=0.725 pd=5.29 as=0.725 ps=5.29 w=5 l=3
X3 M1.G0 ui_in[0].t2 VDPWR.t44 VDPWR.t43 sky130_fd_pr__pfet_01v8 ad=0.348 pd=2.98 as=0.348 ps=2.98 w=1.2 l=1
X4 M1.S1 M1.G0 VDPWR.t5 VDPWR.t4 sky130_fd_pr__pfet_01v8_lvt ad=0.725 pd=5.29 as=0.725 ps=5.29 w=5 l=3
X5 VGND.t36 VGND.t38 RPTAT_lay_0.B sky130_fd_pr__pnp_05v5_W3p40L3p40
**devattr s=462400,2720 d=48607855,56241
X6 M1.S1 M1.G0 VDPWR.t1 VDPWR.t0 sky130_fd_pr__pfet_01v8_lvt ad=0.725 pd=5.29 as=1.45 ps=10.58 w=5 l=3
X7 M1.G0 M1.S1 RCTAT_lay_0.A VGND.t9 sky130_fd_pr__nfet_01v8_lvt ad=0.725 pd=5.29 as=0.725 ps=5.29 w=5 l=3
X8 inv_0.Y ui_in[0].t4 VDPWR.t40 VDPWR.t39 sky130_fd_pr__pfet_01v8 ad=0.58 pd=4.58 as=0.58 ps=4.58 w=2 l=0.5
X9 RL_lay_0.R3.R1 RL_lay_0.sky130_fd_pr__res_xhigh_po_0p35_RTNBCE_0.R2 VGND.t22 sky130_fd_pr__res_xhigh_po_0p35 l=4.18
X10 RCTAT_lay_0.A RCTAT_lay_0.sky130_fd_pr__res_xhigh_po_0p35_7LQ4N7_1.R2 VGND.t18 sky130_fd_pr__res_xhigh_po_0p35 l=4.08
X11 VDPWR.t15 M1.G0 M1.G0 VDPWR.t14 sky130_fd_pr__pfet_01v8_lvt ad=0.725 pd=5.29 as=0.725 ps=5.29 w=5 l=3
X12 VGND.t34 VGND.t33 Q1.Emitter sky130_fd_pr__pnp_05v5_W3p40L3p40
**devattr s=462400,2720 d=48607855,56241
X13 ME2.S ui_in[0].t0 M1.S1 VGND.t29 sky130_fd_pr__nfet_01v8 ad=0.29 pd=2.58 as=0.29 ps=2.58 w=1 l=0.3
X14 RCTAT_lay_0.sky130_fd_pr__res_xhigh_po_0p35_7LQ4N7_2.R1 RCTAT_lay_0.sky130_fd_pr__res_xhigh_po_0p35_7LQ4N7_3.R2 VGND.t25 sky130_fd_pr__res_xhigh_po_0p35 l=4.08
X15 VGND.t41 VGND.t40 RPTAT_lay_0.B sky130_fd_pr__pnp_05v5_W3p40L3p40
**devattr s=462400,2720 d=48607855,56241
X16 VGND.t34 VGND.t42 RPTAT_lay_0.B sky130_fd_pr__pnp_05v5_W3p40L3p40
**devattr s=462400,2720 d=48607855,56241
X17 VDPWR.t19 M1.G0 M1.G0 VDPWR.t18 sky130_fd_pr__pfet_01v8_lvt ad=0.725 pd=5.29 as=0.725 ps=5.29 w=5 l=3
X18 Q1.Emitter M1.S1 M1.S1 VGND.t6 sky130_fd_pr__nfet_01v8_lvt ad=1.45 pd=10.58 as=0.725 ps=5.29 w=5 l=3
X19 RCTAT_lay_0.A M1.S1 M1.G0 VGND.t12 sky130_fd_pr__nfet_01v8_lvt ad=1.45 pd=10.58 as=0.725 ps=5.29 w=5 l=3
X20 ME1.S ui_in[0].t3 VDPWR.t42 VDPWR.t41 sky130_fd_pr__pfet_01v8 ad=0.348 pd=2.98 as=0.348 ps=2.98 w=1.2 l=1
X21 ua[0].t6 RL_lay_0.sky130_fd_pr__res_xhigh_po_0p35_RTNBCE_0.R2 VGND.t26 sky130_fd_pr__res_xhigh_po_0p35 l=4.18
X22 RCTAT_lay_0.A RPTAT_lay_0.B VGND.t0 sky130_fd_pr__res_xhigh_po_0p35 l=3.2
X23 RCTAT_lay_0.sky130_fd_pr__res_xhigh_po_0p35_7LQ4N7_4.R1 RCTAT_lay_0.sky130_fd_pr__res_xhigh_po_0p35_7LQ4N7_5.R2 VGND.t23 sky130_fd_pr__res_xhigh_po_0p35 l=4.08
X24 VDPWR.t3 M1.G0 M1.S1 VDPWR.t2 sky130_fd_pr__pfet_01v8_lvt ad=0.725 pd=5.29 as=0.725 ps=5.29 w=5 l=3
X25 M1.S1 M1.S1 Q1.Emitter VGND.t3 sky130_fd_pr__nfet_01v8_lvt ad=0.725 pd=5.29 as=0.725 ps=5.29 w=5 l=3
X26 RCTAT_lay_0.A M1.S1 M1.G0 VGND.t8 sky130_fd_pr__nfet_01v8_lvt ad=0.725 pd=5.29 as=0.725 ps=5.29 w=5 l=3
X27 VGND.t36 VGND.t35 RPTAT_lay_0.B sky130_fd_pr__pnp_05v5_W3p40L3p40
**devattr s=462400,2720 d=48607855,56241
X28 M1.S1 M1.S1 Q1.Emitter VGND.t1 sky130_fd_pr__nfet_01v8_lvt ad=0.725 pd=5.29 as=1.45 ps=10.58 w=5 l=3
X29 inv_0.Y ui_in[0].t1 VGND.t28 VGND.t27 sky130_fd_pr__nfet_01v8 ad=0.145 pd=1.58 as=0.145 ps=1.58 w=0.5 l=0.5
X30 VGND.t34 VGND.t43 RPTAT_lay_0.B sky130_fd_pr__pnp_05v5_W3p40L3p40
**devattr s=462400,2720 d=48607855,56241
X31 ua[0].t2 M1.G0 VDPWR.t25 VDPWR.t24 sky130_fd_pr__pfet_01v8_lvt ad=0.725 pd=5.29 as=1.45 ps=10.58 w=5 l=3
X32 MSU1.S M1.S1 VGND.t14 VGND.t13 sky130_fd_pr__nfet_01v8 ad=0.29 pd=2.58 as=0.29 ps=2.58 w=1 l=2
X33 M1.G0 ME1.S ME2.S VGND.t15 sky130_fd_pr__nfet_01v8 ad=0.145 pd=1.58 as=0.145 ps=1.58 w=0.5 l=0.15
X34 VGND.t36 VGND.t37 RPTAT_lay_0.B sky130_fd_pr__pnp_05v5_W3p40L3p40
**devattr s=462400,2720 d=48607855,56241
X35 ME1.S ME1.S VDPWR.t38 VDPWR.t37 sky130_fd_pr__pfet_01v8 ad=0.29 pd=2.58 as=0.29 ps=2.58 w=1 l=2
X36 ua[0].t1 M1.G0 VDPWR.t33 VDPWR.t32 sky130_fd_pr__pfet_01v8_lvt ad=0.725 pd=5.29 as=0.725 ps=5.29 w=5 l=3
X37 VDPWR.t35 M1.G0 ua[0].t5 VDPWR.t34 sky130_fd_pr__pfet_01v8_lvt ad=1.45 pd=10.58 as=0.725 ps=5.29 w=5 l=3
X38 M1.G0 M1.G0 VDPWR.t13 VDPWR.t12 sky130_fd_pr__pfet_01v8_lvt ad=0.725 pd=5.29 as=1.45 ps=10.58 w=5 l=3
X39 RCTAT_lay_0.sky130_fd_pr__res_xhigh_po_0p35_7LQ4N7_2.R1 RCTAT_lay_0.sky130_fd_pr__res_xhigh_po_0p35_7LQ4N7_1.R2 VGND.t32 sky130_fd_pr__res_xhigh_po_0p35 l=4.08
X40 VGND.t34 VGND.t39 RPTAT_lay_0.B sky130_fd_pr__pnp_05v5_W3p40L3p40
**devattr s=462400,2720 d=48607855,56241
X41 Q1.Emitter M1.S1 M1.S1 VGND.t2 sky130_fd_pr__nfet_01v8_lvt ad=0.725 pd=5.29 as=0.725 ps=5.29 w=5 l=3
X42 VDPWR.t7 M1.G0 M1.S1 VDPWR.t6 sky130_fd_pr__pfet_01v8_lvt ad=0.725 pd=5.29 as=0.725 ps=5.29 w=5 l=3
X43 M1.S1 M1.G0 VDPWR.t9 VDPWR.t8 sky130_fd_pr__pfet_01v8_lvt ad=0.725 pd=5.29 as=0.725 ps=5.29 w=5 l=3
X44 RCTAT_lay_0.A M1.S1 M1.G0 VGND.t10 sky130_fd_pr__nfet_01v8_lvt ad=0.725 pd=5.29 as=0.725 ps=5.29 w=5 l=3
X45 M1.G0 M1.S1 RCTAT_lay_0.A VGND.t7 sky130_fd_pr__nfet_01v8_lvt ad=0.725 pd=5.29 as=1.45 ps=10.58 w=5 l=3
X46 VDPWR.t27 M1.G0 ua[0].t0 VDPWR.t26 sky130_fd_pr__pfet_01v8_lvt ad=0.725 pd=5.29 as=0.725 ps=5.29 w=5 l=3
X47 ua[0].t4 M1.G0 VDPWR.t29 VDPWR.t28 sky130_fd_pr__pfet_01v8_lvt ad=0.725 pd=5.29 as=0.725 ps=5.29 w=5 l=3
X48 MSU1.S MSU1.S ME1.S VDPWR.t36 sky130_fd_pr__pfet_01v8 ad=0.29 pd=2.58 as=0.29 ps=2.58 w=1 l=2
X49 VGND.t20 RL_lay_0.R4.R2 VGND.t19 sky130_fd_pr__res_xhigh_po_0p35 l=4.18
X50 M1.G0 M1.G0 VDPWR.t21 VDPWR.t20 sky130_fd_pr__pfet_01v8_lvt ad=0.725 pd=5.29 as=0.725 ps=5.29 w=5 l=3
X51 VDPWR.t23 M1.G0 M1.G0 VDPWR.t22 sky130_fd_pr__pfet_01v8_lvt ad=1.45 pd=10.58 as=0.725 ps=5.29 w=5 l=3
X52 M1.S1 inv_0.Y VGND.t17 VGND.t16 sky130_fd_pr__nfet_01v8 ad=0.145 pd=1.58 as=0.145 ps=1.58 w=0.5 l=0.5
X53 RCTAT_lay_0.sky130_fd_pr__res_xhigh_po_0p35_7LQ4N7_4.R1 RCTAT_lay_0.sky130_fd_pr__res_xhigh_po_0p35_7LQ4N7_3.R2 VGND.t24 sky130_fd_pr__res_xhigh_po_0p35 l=4.08
X54 M1.G0 M1.G0 VDPWR.t17 VDPWR.t16 sky130_fd_pr__pfet_01v8_lvt ad=0.725 pd=5.29 as=0.725 ps=5.29 w=5 l=3
X55 VDPWR.t31 M1.G0 ua[0].t3 VDPWR.t30 sky130_fd_pr__pfet_01v8_lvt ad=0.725 pd=5.29 as=0.725 ps=5.29 w=5 l=3
X56 Q1.Emitter M1.S1 M1.S1 VGND.t4 sky130_fd_pr__nfet_01v8_lvt ad=0.725 pd=5.29 as=0.725 ps=5.29 w=5 l=3
X57 M1.S1 M1.S1 Q1.Emitter VGND.t5 sky130_fd_pr__nfet_01v8_lvt ad=0.725 pd=5.29 as=0.725 ps=5.29 w=5 l=3
X58 VGND.t31 RCTAT_lay_0.sky130_fd_pr__res_xhigh_po_0p35_7LQ4N7_5.R2 VGND.t30 sky130_fd_pr__res_xhigh_po_0p35 l=4.08
X59 VGND.t41 VGND.t44 RPTAT_lay_0.B sky130_fd_pr__pnp_05v5_W3p40L3p40
**devattr s=462400,2720 d=48607855,56241
R0 ui_in[0] ui_in[0].t0 274.108
R1 ui_in[0] ui_in[0].t4 248.4
R2 ui_in[0] ui_in[0].t3 180.921
R3 ui_in[0] ui_in[0].t2 180.921
R4 ui_in[0] ui_in[0].t1 176.101
R5 ui_in[0].n7 ui_in[0] 22.8534
R6 ui_in[0] ui_in[0].n6 22.8534
R7 ui_in[0] ui_in[0].n8 14.8416
R8 ui_in[0].n2 ui_in[0] 12.7032
R9 ui_in[0].n3 ui_in[0] 9.5505
R10 ui_in[0].n3 ui_in[0] 9.47907
R11 ui_in[0].n4 ui_in[0] 8.72531
R12 ui_in[0].n6 ui_in[0].n5 4.55586
R13 ui_in[0].n4 ui_in[0] 4.55362
R14 ui_in[0].n8 ui_in[0].n7 4.54514
R15 ui_in[0].n1 ui_in[0].n0 4.5005
R16 ui_in[0].n5 ui_in[0].n4 2.5572
R17 ui_in[0] ui_in[0].n3 0.383312
R18 ui_in[0].n8 ui_in[0].n0 0.0893889
R19 ui_in[0].n5 ui_in[0].n0 0.0893889
R20 ui_in[0].n7 ui_in[0].n1 0.0701429
R21 ui_in[0].n6 ui_in[0].n2 0.0505
R22 ui_in[0].n2 ui_in[0].n1 0.00942857
R23 ua[0].n51 ua[0].n50 585
R24 ua[0].n51 ua[0].n6 585
R25 ua[0].n51 ua[0].n5 585
R26 ua[0].n51 ua[0] 585
R27 ua[0].n51 ua[0].n4 585
R28 ua[0].n51 ua[0].n3 585
R29 ua[0].n52 ua[0].n51 585
R30 ua[0].n27 ua[0].n23 585
R31 ua[0].n27 ua[0] 585
R32 ua[0].n28 ua[0].n27 585
R33 ua[0].n27 ua[0].n26 289.262
R34 ua[0].n27 ua[0].n21 289.26
R35 ua[0].n16 ua[0].n13 192.279
R36 ua[0].n14 ua[0].n13 144.278
R37 ua[0].n56 ua[0].t6 40.8142
R38 ua[0].n56 ua[0] 33.275
R39 ua[0].n53 ua[0].n52 25.4862
R40 ua[0].n50 ua[0].n7 25.4709
R41 ua[0].n16 ua[0].n15 24.5584
R42 ua[0].n21 ua[0].n20 19.6002
R43 ua[0].n26 ua[0].n25 19.5986
R44 ua[0].n49 ua[0].n6 16.5652
R45 ua[0].n3 ua[0].n2 16.5652
R46 ua[0].n8 ua[0].n5 15.0593
R47 ua[0].n36 ua[0].n4 15.0593
R48 ua[0].n25 ua[0].n23 15.0593
R49 ua[0].n28 ua[0].n20 15.0593
R50 ua[0].n26 ua[0].n10 14.6037
R51 ua[0].n21 ua[0].n11 14.5505
R52 ua[0] ua[0].n14 13.7368
R53 ua[0].n42 ua[0] 13.5534
R54 ua[0].n38 ua[0] 13.5534
R55 ua[0].n15 ua[0] 13.5534
R56 ua[0].n22 ua[0] 13.5534
R57 ua[0].n29 ua[0] 13.5534
R58 ua[0].n42 ua[0].n5 12.0476
R59 ua[0].n38 ua[0].n4 12.0476
R60 ua[0].n23 ua[0].n22 12.0476
R61 ua[0].n29 ua[0].n28 12.0476
R62 ua[0].n8 ua[0].n6 10.5417
R63 ua[0].n36 ua[0].n3 10.5417
R64 ua[0].n17 ua[0].n16 9.51453
R65 ua[0].n2 ua[0].n1 9.3005
R66 ua[0].n37 ua[0].n36 9.3005
R67 ua[0].n39 ua[0].n38 9.3005
R68 ua[0].n49 ua[0].n48 9.3005
R69 ua[0].n9 ua[0].n8 9.3005
R70 ua[0].n43 ua[0].n42 9.3005
R71 ua[0].n15 ua[0].n12 9.3005
R72 ua[0].n20 ua[0].n19 9.3005
R73 ua[0].n30 ua[0].n29 9.3005
R74 ua[0].n25 ua[0].n24 9.3005
R75 ua[0].n22 ua[0].n18 9.3005
R76 ua[0].n50 ua[0].n49 9.03579
R77 ua[0].n52 ua[0].n2 9.03579
R78 ua[0].n14 ua[0].n12 6.74741
R79 ua[0].n51 ua[0].t5 5.7135
R80 ua[0].n51 ua[0].t1 5.7135
R81 ua[0].n13 ua[0].t0 5.7135
R82 ua[0].n13 ua[0].t2 5.7135
R83 ua[0].n27 ua[0].t3 5.7135
R84 ua[0].n27 ua[0].t4 5.7135
R85 ua[0].n46 ua[0].n7 4.53859
R86 ua[0].n32 ua[0].n31 4.5005
R87 ua[0].n47 ua[0].n46 4.5005
R88 ua[0].n45 ua[0].n44 4.5005
R89 ua[0].n35 ua[0].n0 4.5005
R90 ua[0].n54 ua[0].n53 4.5005
R91 ua[0].n32 ua[0].n17 1.69172
R92 ua[0].n57 ua[0].n56 1.55639
R93 ua[0].n34 ua[0].n33 1.30258
R94 ua[0].n41 ua[0].n40 1.1255
R95 ua[0].n57 ua[0].n55 0.947605
R96 ua[0].n55 ua[0] 0.921935
R97 ua[0].n33 ua[0].n10 0.84425
R98 ua[0].n33 ua[0].n11 0.84425
R99 ua[0].n55 ua[0].n54 0.531937
R100 ua[0] ua[0].n57 0.26425
R101 ua[0].n39 ua[0].n37 0.0647857
R102 ua[0].n24 ua[0].n18 0.0647857
R103 ua[0].n30 ua[0].n19 0.0647857
R104 ua[0].n19 ua[0].n11 0.0621071
R105 ua[0].n43 ua[0].n41 0.0585357
R106 ua[0].n40 ua[0].n0 0.0576429
R107 ua[0].n31 ua[0].n18 0.05675
R108 ua[0].n45 ua[0].n34 0.0564524
R109 ua[0].n35 ua[0].n1 0.0496071
R110 ua[0].n48 ua[0].n47 0.04425
R111 ua[0].n46 ua[0].n45 0.0385952
R112 ua[0].n54 ua[0].n0 0.0385952
R113 ua[0].n44 ua[0].n9 0.0371071
R114 ua[0].n44 ua[0].n43 0.0281786
R115 ua[0].n47 ua[0].n9 0.0210357
R116 ua[0].n37 ua[0].n35 0.0156786
R117 ua[0].n48 ua[0].n7 0.0138929
R118 ua[0].n24 ua[0].n10 0.0138929
R119 ua[0].n53 ua[0].n1 0.00853571
R120 ua[0].n31 ua[0].n30 0.00853571
R121 ua[0].n41 ua[0].n39 0.00675
R122 ua[0].n33 ua[0].n32 0.00570833
R123 ua[0].n40 ua[0].n34 0.00169048
R124 ua[0].n17 ua[0].n12 0.00139286
R125 VDPWR.n148 VDPWR.n107 9051.59
R126 VDPWR.n130 VDPWR.n127 3068.63
R127 VDPWR.n129 VDPWR.n106 1031.56
R128 VDPWR.t12 VDPWR.t10 638.889
R129 VDPWR VDPWR.t38 613.566
R130 VDPWR VDPWR.t44 608.804
R131 VDPWR VDPWR.t42 608.804
R132 VDPWR.n117 VDPWR.n116 585
R133 VDPWR.n98 VDPWR.n97 585
R134 VDPWR.n97 VDPWR.n90 585
R135 VDPWR.n97 VDPWR.n96 585
R136 VDPWR.n97 VDPWR 585
R137 VDPWR.n86 VDPWR.n85 585
R138 VDPWR.n85 VDPWR.n84 585
R139 VDPWR.n85 VDPWR.n79 585
R140 VDPWR.n85 VDPWR 585
R141 VDPWR.n74 VDPWR.n73 585
R142 VDPWR.n73 VDPWR.n72 585
R143 VDPWR.n73 VDPWR.n67 585
R144 VDPWR.n73 VDPWR 585
R145 VDPWR.n62 VDPWR.n61 585
R146 VDPWR.n61 VDPWR.n54 585
R147 VDPWR.n61 VDPWR.n60 585
R148 VDPWR.n61 VDPWR 585
R149 VDPWR.n50 VDPWR.n49 585
R150 VDPWR.n49 VDPWR.n48 585
R151 VDPWR.n49 VDPWR.n43 585
R152 VDPWR.n49 VDPWR 585
R153 VDPWR.n38 VDPWR.n37 585
R154 VDPWR.n37 VDPWR.n36 585
R155 VDPWR.n37 VDPWR.n31 585
R156 VDPWR.n37 VDPWR 585
R157 VDPWR.n26 VDPWR.n25 585
R158 VDPWR.n25 VDPWR.n18 585
R159 VDPWR.n25 VDPWR.n24 585
R160 VDPWR.n25 VDPWR 585
R161 VDPWR.n14 VDPWR.n13 585
R162 VDPWR.n13 VDPWR.n12 585
R163 VDPWR.n13 VDPWR.n7 585
R164 VDPWR.n13 VDPWR 585
R165 VDPWR.n163 VDPWR.n162 585
R166 VDPWR.n163 VDPWR.n3 585
R167 VDPWR.n163 VDPWR.n2 585
R168 VDPWR VDPWR.n163 585
R169 VDPWR.t22 VDPWR.n146 515.487
R170 VDPWR.n130 VDPWR.n129 496.325
R171 VDPWR.t20 VDPWR.t22 456.945
R172 VDPWR.t18 VDPWR.t20 456.945
R173 VDPWR.t16 VDPWR.t14 456.945
R174 VDPWR.t14 VDPWR.t12 456.945
R175 VDPWR.t10 VDPWR.t8 456.945
R176 VDPWR.t8 VDPWR.t6 456.945
R177 VDPWR.t6 VDPWR.t4 456.945
R178 VDPWR.t4 VDPWR.t2 456.945
R179 VDPWR.t2 VDPWR.t0 456.945
R180 VDPWR.t32 VDPWR.t34 405.45
R181 VDPWR.n116 VDPWR.n115 292.476
R182 VDPWR.n138 VDPWR.n137 281.416
R183 VDPWR.n112 VDPWR.n106 280.401
R184 VDPWR.n136 VDPWR.n127 259.389
R185 VDPWR.n143 VDPWR.n111 240
R186 VDPWR.n139 VDPWR.n110 240
R187 VDPWR.n147 VDPWR.t16 229.862
R188 VDPWR.n147 VDPWR.t18 227.083
R189 VDPWR.t39 VDPWR.t41 217.619
R190 VDPWR.n13 VDPWR.n6 197.698
R191 VDPWR.n163 VDPWR.n1 197.698
R192 VDPWR.n85 VDPWR.n78 197.698
R193 VDPWR.n73 VDPWR.n66 197.698
R194 VDPWR.n25 VDPWR.n19 197.698
R195 VDPWR.n97 VDPWR.n91 197.698
R196 VDPWR.n49 VDPWR.n42 197.698
R197 VDPWR.n37 VDPWR.n30 197.698
R198 VDPWR.n61 VDPWR.n55 197.698
R199 VDPWR.t26 VDPWR.t43 192.381
R200 VDPWR.n143 VDPWR.n142 185
R201 VDPWR.n141 VDPWR.n111 185
R202 VDPWR.n140 VDPWR.n139 185
R203 VDPWR.n138 VDPWR.n110 185
R204 VDPWR.t30 VDPWR.t37 183.81
R205 VDPWR.n144 VDPWR.n110 175.21
R206 VDPWR.n144 VDPWR.n143 175.21
R207 VDPWR.n137 VDPWR.n136 170.166
R208 VDPWR.t28 VDPWR.t36 170
R209 VDPWR.t36 VDPWR.t30 143.333
R210 VDPWR.t37 VDPWR.t32 129.524
R211 VDPWR.n137 VDPWR.n126 109.382
R212 VDPWR.t43 VDPWR.n108 106.668
R213 VDPWR.n136 VDPWR.n135 103.468
R214 VDPWR.n155 VDPWR.t35 92.781
R215 VDPWR.n152 VDPWR.t23 92.2351
R216 VDPWR.n102 VDPWR.t11 92.2351
R217 VDPWR.n131 VDPWR.n130 84.778
R218 VDPWR.n142 VDPWR.n112 79.0593
R219 VDPWR.n149 VDPWR.n106 74.5185
R220 VDPWR.n111 VDPWR.n109 72.7879
R221 VDPWR.n139 VDPWR.n109 72.7879
R222 VDPWR.n132 VDPWR.n131 61.9487
R223 VDPWR.n132 VDPWR.n127 59.4678
R224 VDPWR.n145 VDPWR.n109 56.1076
R225 VDPWR.t41 VDPWR.t26 51.4291
R226 VDPWR.t24 VDPWR.t39 44.2862
R227 VDPWR.n135 VDPWR.n126 40.1093
R228 VDPWR.n129 VDPWR.n128 39.9483
R229 VDPWR.n134 VDPWR.n133 27.9709
R230 VDPWR.n117 VDPWR 25.6005
R231 VDPWR.n142 VDPWR.n141 25.6005
R232 VDPWR.n141 VDPWR.n140 25.6005
R233 VDPWR.n140 VDPWR.n138 25.6005
R234 VDPWR.n99 VDPWR.n98 25.3691
R235 VDPWR.n87 VDPWR.n86 25.3691
R236 VDPWR.n75 VDPWR.n74 25.3691
R237 VDPWR.n63 VDPWR.n62 25.3691
R238 VDPWR.n51 VDPWR.n50 25.3691
R239 VDPWR.n39 VDPWR.n38 25.3691
R240 VDPWR.n27 VDPWR.n26 25.3691
R241 VDPWR.n15 VDPWR.n14 25.3691
R242 VDPWR.n162 VDPWR.n156 25.3691
R243 VDPWR.n128 VDPWR 21.4028
R244 VDPWR.n55 VDPWR 18.8127
R245 VDPWR.n91 VDPWR 18.8127
R246 VDPWR VDPWR.n42 18.8127
R247 VDPWR VDPWR.n30 18.8127
R248 VDPWR VDPWR.n78 18.8127
R249 VDPWR VDPWR.n66 18.8127
R250 VDPWR.n19 VDPWR 18.8127
R251 VDPWR VDPWR.n6 18.8127
R252 VDPWR VDPWR.n1 18.8127
R253 VDPWR.n146 VDPWR.t24 17.1844
R254 VDPWR.n90 VDPWR.n89 16.5652
R255 VDPWR.n84 VDPWR.n77 16.5652
R256 VDPWR.n72 VDPWR.n65 16.5652
R257 VDPWR.n54 VDPWR.n53 16.5652
R258 VDPWR.n48 VDPWR.n41 16.5652
R259 VDPWR.n36 VDPWR.n29 16.5652
R260 VDPWR.n18 VDPWR.n17 16.5652
R261 VDPWR.n12 VDPWR.n5 16.5652
R262 VDPWR.n161 VDPWR.n3 16.5652
R263 VDPWR.n134 VDPWR 16.0927
R264 VDPWR.n96 VDPWR.n92 15.0593
R265 VDPWR.n83 VDPWR.n79 15.0593
R266 VDPWR.n71 VDPWR.n67 15.0593
R267 VDPWR.n60 VDPWR.n56 15.0593
R268 VDPWR.n47 VDPWR.n43 15.0593
R269 VDPWR.n35 VDPWR.n31 15.0593
R270 VDPWR.n24 VDPWR.n20 15.0593
R271 VDPWR.n11 VDPWR.n7 15.0593
R272 VDPWR.n158 VDPWR.n2 15.0593
R273 VDPWR.n146 VDPWR.n145 14.3767
R274 VDPWR.n108 VDPWR.t28 14.2862
R275 VDPWR.n116 VDPWR.t40 14.283
R276 VDPWR.n95 VDPWR 13.5534
R277 VDPWR.n80 VDPWR 13.5534
R278 VDPWR.n68 VDPWR 13.5534
R279 VDPWR.n59 VDPWR 13.5534
R280 VDPWR.n44 VDPWR 13.5534
R281 VDPWR.n32 VDPWR 13.5534
R282 VDPWR.n23 VDPWR 13.5534
R283 VDPWR.n8 VDPWR 13.5534
R284 VDPWR VDPWR.n0 13.5534
R285 VDPWR.n96 VDPWR.n95 12.0476
R286 VDPWR.n80 VDPWR.n79 12.0476
R287 VDPWR.n68 VDPWR.n67 12.0476
R288 VDPWR.n60 VDPWR.n59 12.0476
R289 VDPWR.n44 VDPWR.n43 12.0476
R290 VDPWR.n32 VDPWR.n31 12.0476
R291 VDPWR.n24 VDPWR.n23 12.0476
R292 VDPWR.n8 VDPWR.n7 12.0476
R293 VDPWR.n2 VDPWR.n0 12.0476
R294 VDPWR.n92 VDPWR.n90 10.5417
R295 VDPWR.n84 VDPWR.n83 10.5417
R296 VDPWR.n72 VDPWR.n71 10.5417
R297 VDPWR.n56 VDPWR.n54 10.5417
R298 VDPWR.n48 VDPWR.n47 10.5417
R299 VDPWR.n36 VDPWR.n35 10.5417
R300 VDPWR.n20 VDPWR.n18 10.5417
R301 VDPWR.n12 VDPWR.n11 10.5417
R302 VDPWR.n158 VDPWR.n3 10.5417
R303 VDPWR.n135 VDPWR.n134 9.95606
R304 VDPWR.n120 VDPWR.n114 9.3005
R305 VDPWR.n122 VDPWR.n121 9.3005
R306 VDPWR.n123 VDPWR.n113 9.3005
R307 VDPWR.n125 VDPWR.n124 9.3005
R308 VDPWR.n89 VDPWR.n88 9.3005
R309 VDPWR.n93 VDPWR.n92 9.3005
R310 VDPWR.n95 VDPWR.n94 9.3005
R311 VDPWR.n77 VDPWR.n76 9.3005
R312 VDPWR.n83 VDPWR.n82 9.3005
R313 VDPWR.n81 VDPWR.n80 9.3005
R314 VDPWR.n65 VDPWR.n64 9.3005
R315 VDPWR.n71 VDPWR.n70 9.3005
R316 VDPWR.n69 VDPWR.n68 9.3005
R317 VDPWR.n53 VDPWR.n52 9.3005
R318 VDPWR.n57 VDPWR.n56 9.3005
R319 VDPWR.n59 VDPWR.n58 9.3005
R320 VDPWR.n41 VDPWR.n40 9.3005
R321 VDPWR.n47 VDPWR.n46 9.3005
R322 VDPWR.n45 VDPWR.n44 9.3005
R323 VDPWR.n29 VDPWR.n28 9.3005
R324 VDPWR.n35 VDPWR.n34 9.3005
R325 VDPWR.n33 VDPWR.n32 9.3005
R326 VDPWR.n17 VDPWR.n16 9.3005
R327 VDPWR.n21 VDPWR.n20 9.3005
R328 VDPWR.n23 VDPWR.n22 9.3005
R329 VDPWR.n5 VDPWR.n4 9.3005
R330 VDPWR.n11 VDPWR.n10 9.3005
R331 VDPWR.n9 VDPWR.n8 9.3005
R332 VDPWR.n161 VDPWR.n160 9.3005
R333 VDPWR.n159 VDPWR.n158 9.3005
R334 VDPWR.n157 VDPWR.n0 9.3005
R335 VDPWR.n98 VDPWR.n89 9.03579
R336 VDPWR.n86 VDPWR.n77 9.03579
R337 VDPWR.n74 VDPWR.n65 9.03579
R338 VDPWR.n62 VDPWR.n53 9.03579
R339 VDPWR.n50 VDPWR.n41 9.03579
R340 VDPWR.n38 VDPWR.n29 9.03579
R341 VDPWR.n26 VDPWR.n17 9.03579
R342 VDPWR.n14 VDPWR.n5 9.03579
R343 VDPWR.n162 VDPWR.n161 9.03579
R344 VDPWR.n118 VDPWR.n117 8.88299
R345 VDPWR.n131 VDPWR.n128 8.11358
R346 VDPWR.n120 VDPWR.n119 7.23727
R347 VDPWR.n124 VDPWR 6.75561
R348 VDPWR.n97 VDPWR.t1 5.7135
R349 VDPWR.n85 VDPWR.t5 5.7135
R350 VDPWR.n85 VDPWR.t3 5.7135
R351 VDPWR.n73 VDPWR.t9 5.7135
R352 VDPWR.n73 VDPWR.t7 5.7135
R353 VDPWR.n61 VDPWR.t13 5.7135
R354 VDPWR.n49 VDPWR.t17 5.7135
R355 VDPWR.n49 VDPWR.t15 5.7135
R356 VDPWR.n37 VDPWR.t21 5.7135
R357 VDPWR.n37 VDPWR.t19 5.7135
R358 VDPWR.n25 VDPWR.t25 5.7135
R359 VDPWR.n13 VDPWR.t29 5.7135
R360 VDPWR.n13 VDPWR.t27 5.7135
R361 VDPWR.n163 VDPWR.t33 5.7135
R362 VDPWR.n163 VDPWR.t31 5.7135
R363 VDPWR.n125 VDPWR.n113 5.20728
R364 VDPWR.n121 VDPWR.n113 5.20728
R365 VDPWR.n121 VDPWR.n120 5.20728
R366 VDPWR.n145 VDPWR.n144 4.89628
R367 VDPWR.n118 VDPWR.n115 4.86725
R368 VDPWR.n133 VDPWR.n107 4.5127
R369 VDPWR.n108 VDPWR.n107 4.5127
R370 VDPWR.n133 VDPWR.n132 3.97871
R371 VDPWR.n119 VDPWR 3.66716
R372 VDPWR.n119 VDPWR.n112 2.83752
R373 VDPWR.n105 VDPWR 2.71026
R374 VDPWR VDPWR.n115 2.6809
R375 VDPWR.n9 VDPWR.n6 2.16295
R376 VDPWR.n157 VDPWR.n1 2.16295
R377 VDPWR.n81 VDPWR.n78 2.16293
R378 VDPWR.n69 VDPWR.n66 2.16293
R379 VDPWR.n22 VDPWR.n19 2.16293
R380 VDPWR.n94 VDPWR.n91 2.16292
R381 VDPWR.n33 VDPWR.n30 2.16292
R382 VDPWR.n45 VDPWR.n42 2.16292
R383 VDPWR.n58 VDPWR.n55 2.16292
R384 VDPWR.n126 VDPWR.n125 1.80841
R385 VDPWR.n100 VDPWR.n99 1.0348
R386 VDPWR.n149 VDPWR.n148 1.0005
R387 VDPWR.n148 VDPWR.n147 1.0005
R388 VDPWR.n102 VDPWR.n101 0.554667
R389 VDPWR.n155 VDPWR.n154 0.5505
R390 VDPWR.n154 VDPWR.n153 0.5505
R391 VDPWR.n152 VDPWR.n151 0.5505
R392 VDPWR.n104 VDPWR.n103 0.546333
R393 VDPWR.n101 VDPWR.n100 0.546333
R394 VDPWR.n100 VDPWR.n87 0.488969
R395 VDPWR.n101 VDPWR.n75 0.488969
R396 VDPWR.n103 VDPWR.n63 0.488969
R397 VDPWR.n104 VDPWR.n51 0.488969
R398 VDPWR.n151 VDPWR.n39 0.488969
R399 VDPWR.n153 VDPWR.n27 0.488969
R400 VDPWR.n154 VDPWR.n15 0.488969
R401 VDPWR.n156 VDPWR.n155 0.488969
R402 VDPWR VDPWR.n118 0.420852
R403 VDPWR.n151 VDPWR.n150 0.271333
R404 VDPWR.n105 VDPWR.n104 0.271333
R405 VDPWR.n99 VDPWR.n88 0.143564
R406 VDPWR.n87 VDPWR.n76 0.143564
R407 VDPWR.n75 VDPWR.n64 0.143564
R408 VDPWR.n63 VDPWR.n52 0.143564
R409 VDPWR.n51 VDPWR.n40 0.143564
R410 VDPWR.n39 VDPWR.n28 0.143564
R411 VDPWR.n27 VDPWR.n16 0.143564
R412 VDPWR.n15 VDPWR.n4 0.143564
R413 VDPWR.n160 VDPWR.n156 0.143564
R414 VDPWR.n93 VDPWR.n88 0.113
R415 VDPWR.n94 VDPWR.n93 0.113
R416 VDPWR.n82 VDPWR.n76 0.113
R417 VDPWR.n82 VDPWR.n81 0.113
R418 VDPWR.n70 VDPWR.n64 0.113
R419 VDPWR.n70 VDPWR.n69 0.113
R420 VDPWR.n57 VDPWR.n52 0.113
R421 VDPWR.n58 VDPWR.n57 0.113
R422 VDPWR.n46 VDPWR.n40 0.113
R423 VDPWR.n46 VDPWR.n45 0.113
R424 VDPWR.n34 VDPWR.n28 0.113
R425 VDPWR.n34 VDPWR.n33 0.113
R426 VDPWR.n21 VDPWR.n16 0.113
R427 VDPWR.n22 VDPWR.n21 0.113
R428 VDPWR.n10 VDPWR.n4 0.113
R429 VDPWR.n10 VDPWR.n9 0.113
R430 VDPWR.n160 VDPWR.n159 0.113
R431 VDPWR.n159 VDPWR.n157 0.113
R432 VDPWR.n153 VDPWR.n152 0.108833
R433 VDPWR.n103 VDPWR.n102 0.108833
R434 VDPWR.n124 VDPWR.n123 0.0534412
R435 VDPWR.n123 VDPWR.n122 0.0534412
R436 VDPWR.n122 VDPWR.n114 0.0534412
R437 VDPWR VDPWR.n114 0.0328529
R438 VDPWR.n150 VDPWR.n149 0.0272241
R439 VDPWR.n150 VDPWR.n105 0.00466667
R440 VGND.n2016 VGND.n12 1.03126e+06
R441 VGND.n482 VGND.n12 466973
R442 VGND.n2015 VGND.t12 17193.8
R443 VGND.n1865 VGND.n200 11491.7
R444 VGND.n1865 VGND.n185 11130.5
R445 VGND.n1438 VGND.n245 9752.81
R446 VGND.n245 VGND.n243 9653
R447 VGND.n1779 VGND.n246 4684.8
R448 VGND.n2018 VGND.n11 3709.19
R449 VGND.n1735 VGND.n1734 3242.67
R450 VGND.n1734 VGND.n1733 3178.67
R451 VGND.n1736 VGND.n1735 3136
R452 VGND.n1737 VGND.n1736 3093.33
R453 VGND.n1733 VGND.n1732 2752.62
R454 VGND.n1737 VGND.n246 2589.87
R455 VGND.n1732 VGND.n31 2024.28
R456 VGND.n2013 VGND.n31 1825.1
R457 VGND.n1755 VGND.n273 1221.1
R458 VGND.n201 VGND.n180 1170.95
R459 VGND.n2015 VGND.n2014 1170
R460 VGND.n1507 VGND.n1506 1007.63
R461 VGND.n1507 VGND.n1501 1007.63
R462 VGND.n1513 VGND.n1501 1007.63
R463 VGND.n1514 VGND.n1513 1007.63
R464 VGND.n1515 VGND.n1514 1007.63
R465 VGND.n1521 VGND.n1499 1007.63
R466 VGND.n1522 VGND.n1521 1007.63
R467 VGND.n1524 VGND.n1522 1007.63
R468 VGND.n1524 VGND.n1523 1007.63
R469 VGND.n1523 VGND.n272 1007.63
R470 VGND.n1577 VGND.n273 968.808
R471 VGND.n1646 VGND.n1645 908.258
R472 VGND.n1645 VGND.n1644 908.258
R473 VGND.n1644 VGND.n1470 908.258
R474 VGND.n1547 VGND.n1470 908.258
R475 VGND.n1548 VGND.n1547 908.258
R476 VGND.n1558 VGND.n1557 908.258
R477 VGND.n1558 VGND.n1531 908.258
R478 VGND.n1564 VGND.n1531 908.258
R479 VGND.n1578 VGND.n1564 908.258
R480 VGND.n1578 VGND.n1577 908.258
R481 VGND.n1910 VGND.n1909 876.106
R482 VGND.n1909 VGND.n1908 876.106
R483 VGND.n1908 VGND.n161 876.106
R484 VGND.n1902 VGND.n161 876.106
R485 VGND.n1902 VGND.n1901 876.106
R486 VGND.n1898 VGND.n170 876.106
R487 VGND.n176 VGND.n170 876.106
R488 VGND.n1891 VGND.n176 876.106
R489 VGND.n1891 VGND.n1890 876.106
R490 VGND.n1890 VGND.n1889 876.106
R491 VGND.n1439 VGND.n1438 800.509
R492 VGND.n1499 VGND.t34 682.952
R493 VGND.t34 VGND.n1 2.96735
R494 VGND.n1942 VGND.n92 642.553
R495 VGND.n860 VGND.n77 642.553
R496 VGND.n3 VGND.n542 1.98592
R497 VGND.n1942 VGND.n1941 638.298
R498 VGND.n820 VGND.n77 638.298
R499 VGND.n542 VGND.n265 638.298
R500 VGND.n947 VGND.n738 629.801
R501 VGND.n947 VGND.n818 602.707
R502 VGND.n1898 VGND.t41 593.806
R503 VGND.n1791 VGND.n227 592.254
R504 VGND.n183 VGND.n182 589.514
R505 VGND.n1580 VGND.n1494 585
R506 VGND.n1578 VGND.n1494 585
R507 VGND.n1563 VGND.n1493 585
R508 VGND.n1564 VGND.n1563 585
R509 VGND.n1562 VGND.n1561 585
R510 VGND.n1562 VGND.n1531 585
R511 VGND.n1538 VGND.n1532 585
R512 VGND.n1558 VGND.n1532 585
R513 VGND.n1556 VGND.n1555 585
R514 VGND.n1557 VGND.n1556 585
R515 VGND.n1550 VGND.n1539 585
R516 VGND.n1548 VGND.n1539 585
R517 VGND.n1546 VGND.n1545 585
R518 VGND.n1547 VGND.n1546 585
R519 VGND.n1543 VGND.n1473 585
R520 VGND.n1543 VGND.n1470 585
R521 VGND.n1642 VGND.n1469 585
R522 VGND.n1644 VGND.n1469 585
R523 VGND.n1634 VGND.n1468 585
R524 VGND.n1645 VGND.n1468 585
R525 VGND.n1580 VGND.n1579 585
R526 VGND.n1579 VGND.n1578 585
R527 VGND.n1495 VGND.n1493 585
R528 VGND.n1564 VGND.n1495 585
R529 VGND.n1561 VGND.n1560 585
R530 VGND.n1560 VGND.n1531 585
R531 VGND.n1559 VGND.n1538 585
R532 VGND.n1559 VGND.n1558 585
R533 VGND.n1555 VGND.n1537 585
R534 VGND.n1557 VGND.n1537 585
R535 VGND.n1550 VGND.n1549 585
R536 VGND.n1549 VGND.n1548 585
R537 VGND.n1545 VGND.n1542 585
R538 VGND.n1547 VGND.n1542 585
R539 VGND.n1473 VGND.n1471 585
R540 VGND.n1471 VGND.n1470 585
R541 VGND.n1643 VGND.n1642 585
R542 VGND.n1644 VGND.n1643 585
R543 VGND.n1634 VGND.n557 585
R544 VGND.n1645 VGND.n557 585
R545 VGND.n1946 VGND.n1945 585
R546 VGND.n1945 VGND.n1944 585
R547 VGND.n1947 VGND.n88 585
R548 VGND.n88 VGND.n87 585
R549 VGND.n1949 VGND.n1948 585
R550 VGND.n1950 VGND.n1949 585
R551 VGND.n85 VGND.n84 585
R552 VGND.n1951 VGND.n85 585
R553 VGND.n1954 VGND.n1953 585
R554 VGND.n1953 VGND.n1952 585
R555 VGND.n1955 VGND.n83 585
R556 VGND.n86 VGND.n83 585
R557 VGND.n1957 VGND.n1956 585
R558 VGND.n1958 VGND.n1957 585
R559 VGND.n81 VGND.n80 585
R560 VGND.n1959 VGND.n81 585
R561 VGND.n1962 VGND.n1961 585
R562 VGND.n1961 VGND.n1960 585
R563 VGND.n1963 VGND.n79 585
R564 VGND.n82 VGND.n79 585
R565 VGND.n1965 VGND.n1964 585
R566 VGND.n1965 VGND.n78 585
R567 VGND.n1966 VGND.n72 585
R568 VGND.n1967 VGND.n1966 585
R569 VGND.n339 VGND.n338 585
R570 VGND.n411 VGND.n337 585
R571 VGND.n336 VGND.n334 585
R572 VGND.n418 VGND.n333 585
R573 VGND.n332 VGND.n330 585
R574 VGND.n425 VGND.n329 585
R575 VGND.n328 VGND.n326 585
R576 VGND.n432 VGND.n325 585
R577 VGND.n324 VGND.n321 585
R578 VGND.n439 VGND.n438 585
R579 VGND.n339 VGND.n295 585
R580 VGND.n411 VGND.n410 585
R581 VGND.n409 VGND.n334 585
R582 VGND.n418 VGND.n417 585
R583 VGND.n416 VGND.n330 585
R584 VGND.n425 VGND.n424 585
R585 VGND.n423 VGND.n326 585
R586 VGND.n432 VGND.n431 585
R587 VGND.n430 VGND.n321 585
R588 VGND.n438 VGND.n437 585
R589 VGND.n1300 VGND.n585 585
R590 VGND.n1299 VGND.n1298 585
R591 VGND.n1289 VGND.n1288 585
R592 VGND.n1287 VGND.n1286 585
R593 VGND.n1281 VGND.n1280 585
R594 VGND.n1279 VGND.n1278 585
R595 VGND.n692 VGND.n691 585
R596 VGND.n690 VGND.n594 585
R597 VGND.n666 VGND.n593 585
R598 VGND.n1305 VGND.n1304 585
R599 VGND.n665 VGND.n592 585
R600 VGND.n1314 VGND.n1313 585
R601 VGND.n688 VGND.n591 585
R602 VGND.n694 VGND.n693 585
R603 VGND.n685 VGND.n684 585
R604 VGND.n687 VGND.n686 585
R605 VGND.n683 VGND.n682 585
R606 VGND.n681 VGND.n680 585
R607 VGND.n1297 VGND.n586 585
R608 VGND.n1319 VGND.n1318 585
R609 VGND.n1465 VGND.n555 585
R610 VGND.n1465 VGND.n265 585
R611 VGND.n1464 VGND.n1463 585
R612 VGND.n1332 VGND.n559 585
R613 VGND.n1333 VGND.n1330 585
R614 VGND.n1456 VGND.n1335 585
R615 VGND.n1455 VGND.n1336 585
R616 VGND.n1454 VGND.n1338 585
R617 VGND.n1342 VGND.n1339 585
R618 VGND.n1449 VGND.n1344 585
R619 VGND.n1448 VGND.n1345 585
R620 VGND.n1447 VGND.n1347 585
R621 VGND.n1447 VGND.n1446 585
R622 VGND.n1448 VGND.n1341 585
R623 VGND.n1450 VGND.n1449 585
R624 VGND.n1452 VGND.n1339 585
R625 VGND.n1454 VGND.n1453 585
R626 VGND.n1455 VGND.n1331 585
R627 VGND.n1457 VGND.n1456 585
R628 VGND.n1459 VGND.n1330 585
R629 VGND.n1460 VGND.n559 585
R630 VGND.n1463 VGND.n1462 585
R631 VGND.n1328 VGND.n555 585
R632 VGND.n1329 VGND.n1328 585
R633 VGND.n1467 VGND.n556 585
R634 VGND.n1646 VGND.n1467 585
R635 VGND.n1649 VGND.n544 585
R636 VGND.n1658 VGND.n544 585
R637 VGND.n1327 VGND.n554 585
R638 VGND.n1322 VGND.n560 585
R639 VGND.n1324 VGND.n1323 585
R640 VGND.n1321 VGND.n583 585
R641 VGND.n1649 VGND.n1648 585
R642 VGND.n1647 VGND.n556 585
R643 VGND.n1647 VGND.n1646 585
R644 VGND.n1653 VGND.n553 585
R645 VGND.n1654 VGND.n552 585
R646 VGND.n1655 VGND.n551 585
R647 VGND.n580 VGND.n550 585
R648 VGND.n579 VGND.n578 585
R649 VGND.n575 VGND.n564 585
R650 VGND.n574 VGND.n571 585
R651 VGND.n570 VGND.n569 585
R652 VGND.n568 VGND.n566 585
R653 VGND.n565 VGND.n540 585
R654 VGND.n1661 VGND.n539 585
R655 VGND.n1661 VGND.n1660 585
R656 VGND.n541 VGND.n540 585
R657 VGND.n568 VGND.n567 585
R658 VGND.n572 VGND.n569 585
R659 VGND.n574 VGND.n573 585
R660 VGND.n576 VGND.n575 585
R661 VGND.n578 VGND.n577 585
R662 VGND.n550 VGND.n549 585
R663 VGND.n1656 VGND.n1655 585
R664 VGND.n1654 VGND.n548 585
R665 VGND.n1653 VGND.n1652 585
R666 VGND.n1670 VGND.n1669 585
R667 VGND.n463 VGND.n105 585
R668 VGND.n1936 VGND.n105 585
R669 VGND.n440 VGND.n101 585
R670 VGND.n441 VGND.n440 585
R671 VGND.n1938 VGND.n1937 585
R672 VGND.n1937 VGND.n1936 585
R673 VGND.n1665 VGND.n92 585
R674 VGND.n1667 VGND.n1666 585
R675 VGND.n1941 VGND.n1940 585
R676 VGND.n101 VGND.n99 585
R677 VGND.n1707 VGND.n99 585
R678 VGND.n469 VGND.n90 585
R679 VGND.n1943 VGND.n90 585
R680 VGND.n537 VGND.n536 585
R681 VGND.n534 VGND.n464 585
R682 VGND.n533 VGND.n531 585
R683 VGND.n529 VGND.n465 585
R684 VGND.n527 VGND.n526 585
R685 VGND.n523 VGND.n466 585
R686 VGND.n520 VGND.n519 585
R687 VGND.n517 VGND.n467 585
R688 VGND.n515 VGND.n514 585
R689 VGND.n511 VGND.n468 585
R690 VGND.n468 VGND.n92 585
R691 VGND.n470 VGND.n469 585
R692 VGND.n470 VGND.n91 585
R693 VGND.n511 VGND.n510 585
R694 VGND.n514 VGND.n513 585
R695 VGND.n512 VGND.n467 585
R696 VGND.n521 VGND.n520 585
R697 VGND.n523 VGND.n522 585
R698 VGND.n526 VGND.n525 585
R699 VGND.n524 VGND.n465 585
R700 VGND.n533 VGND.n532 585
R701 VGND.n534 VGND.n93 585
R702 VGND.n1941 VGND.n93 585
R703 VGND.n536 VGND.n535 585
R704 VGND.n486 VGND.n485 585
R705 VGND.n485 VGND.n484 585
R706 VGND.n488 VGND.n487 585
R707 VGND.n489 VGND.n488 585
R708 VGND.n481 VGND.n480 585
R709 VGND.n490 VGND.n481 585
R710 VGND.n493 VGND.n492 585
R711 VGND.n492 VGND.n491 585
R712 VGND.n494 VGND.n479 585
R713 VGND.n479 VGND.n478 585
R714 VGND.n496 VGND.n495 585
R715 VGND.n497 VGND.n496 585
R716 VGND.n476 VGND.n475 585
R717 VGND.n498 VGND.n476 585
R718 VGND.n501 VGND.n500 585
R719 VGND.n500 VGND.n499 585
R720 VGND.n502 VGND.n473 585
R721 VGND.n477 VGND.n473 585
R722 VGND.n504 VGND.n503 585
R723 VGND.n505 VGND.n504 585
R724 VGND.n474 VGND.n471 585
R725 VGND.n506 VGND.n471 585
R726 VGND.n508 VGND.n472 585
R727 VGND.n508 VGND.n507 585
R728 VGND.n288 VGND.n286 585
R729 VGND.n483 VGND.n288 585
R730 VGND.n1714 VGND.n1713 585
R731 VGND.n1715 VGND.n292 585
R732 VGND.n1717 VGND.n1716 585
R733 VGND.n1719 VGND.n291 585
R734 VGND.n1720 VGND.n285 585
R735 VGND.n1722 VGND.n284 585
R736 VGND.n1724 VGND.n1723 585
R737 VGND.n1726 VGND.n290 585
R738 VGND.n1727 VGND.n287 585
R739 VGND.n1730 VGND.n1729 585
R740 VGND.n314 VGND.n283 585
R741 VGND.n441 VGND.n314 585
R742 VGND.n1503 VGND.n104 585
R743 VGND.n1936 VGND.n104 585
R744 VGND.n1710 VGND.n1709 585
R745 VGND.n1712 VGND.n293 585
R746 VGND.n1708 VGND.n282 585
R747 VGND.n1708 VGND.n1707 585
R748 VGND.n1527 VGND.n1496 585
R749 VGND.n1523 VGND.n1496 585
R750 VGND.n1526 VGND.n1525 585
R751 VGND.n1525 VGND.n1524 585
R752 VGND.n1498 VGND.n1497 585
R753 VGND.n1522 VGND.n1498 585
R754 VGND.n1520 VGND.n1519 585
R755 VGND.n1521 VGND.n1520 585
R756 VGND.n1518 VGND.n1517 585
R757 VGND.n1517 VGND.n1499 585
R758 VGND.n1516 VGND.n280 585
R759 VGND.n1516 VGND.n1515 585
R760 VGND.n1500 VGND.n279 585
R761 VGND.n1514 VGND.n1500 585
R762 VGND.n1512 VGND.n1511 585
R763 VGND.n1513 VGND.n1512 585
R764 VGND.n1510 VGND.n1502 585
R765 VGND.n1502 VGND.n1501 585
R766 VGND.n1509 VGND.n1508 585
R767 VGND.n1508 VGND.n1507 585
R768 VGND.n1505 VGND.n1504 585
R769 VGND.n1506 VGND.n1505 585
R770 VGND.n1576 VGND.n278 585
R771 VGND.n1577 VGND.n1576 585
R772 VGND.n1575 VGND.n1574 585
R773 VGND.n1575 VGND.n273 585
R774 VGND.n1529 VGND.n1528 585
R775 VGND.n1529 VGND.n272 585
R776 VGND.n1530 VGND.n277 585
R777 VGND.n1577 VGND.n1530 585
R778 VGND.n1436 VGND.n1435 585
R779 VGND.n1436 VGND.n265 585
R780 VGND.n1445 VGND.n1444 585
R781 VGND.n1445 VGND.n1329 585
R782 VGND.n1751 VGND.n274 585
R783 VGND.n1749 VGND.n1748 585
R784 VGND.n1747 VGND.n1746 585
R785 VGND.n1745 VGND.n1744 585
R786 VGND.n1743 VGND.n1742 585
R787 VGND.n1741 VGND.n1740 585
R788 VGND.n1739 VGND.n1738 585
R789 VGND.n1566 VGND.n275 585
R790 VGND.n1568 VGND.n1567 585
R791 VGND.n1570 VGND.n1569 585
R792 VGND.n1572 VGND.n1571 585
R793 VGND.n1573 VGND.n1565 585
R794 VGND.n1753 VGND.n1752 585
R795 VGND.n1754 VGND.n1753 585
R796 VGND.n256 VGND.n253 585
R797 VGND.n253 VGND.n252 585
R798 VGND.n1772 VGND.n1771 585
R799 VGND.n1773 VGND.n1772 585
R800 VGND.n254 VGND.n250 585
R801 VGND.n1774 VGND.n250 585
R802 VGND.n1777 VGND.n1776 585
R803 VGND.n1776 VGND.n1775 585
R804 VGND.n258 VGND.n249 585
R805 VGND.n251 VGND.n249 585
R806 VGND.n1759 VGND.n1758 585
R807 VGND.n1758 VGND.n1757 585
R808 VGND.n263 VGND.n261 585
R809 VGND.n264 VGND.n263 585
R810 VGND.n1428 VGND.n1427 585
R811 VGND.n1429 VGND.n1428 585
R812 VGND.n1354 VGND.n1352 585
R813 VGND.n1430 VGND.n1352 585
R814 VGND.n1433 VGND.n1432 585
R815 VGND.n1432 VGND.n1431 585
R816 VGND.n1434 VGND.n1350 585
R817 VGND.n1353 VGND.n1350 585
R818 VGND.n1443 VGND.n1442 585
R819 VGND.n1442 VGND.n1441 585
R820 VGND.n1089 VGND.n1055 585
R821 VGND.n1148 VGND.n1147 585
R822 VGND.n1083 VGND.n1054 585
R823 VGND.n1079 VGND.n1078 585
R824 VGND.n1073 VGND.n1072 585
R825 VGND.n1071 VGND.n1070 585
R826 VGND.n1065 VGND.n1064 585
R827 VGND.n1063 VGND.n705 585
R828 VGND.n728 VGND.n704 585
R829 VGND.n1153 VGND.n1152 585
R830 VGND.n812 VGND.n811 585
R831 VGND.n810 VGND.n809 585
R832 VGND.n808 VGND.n807 585
R833 VGND.n802 VGND.n801 585
R834 VGND.n800 VGND.n799 585
R835 VGND.n794 VGND.n793 585
R836 VGND.n792 VGND.n757 585
R837 VGND.n756 VGND.n743 585
R838 VGND.n1016 VGND.n1015 585
R839 VGND.n1000 VGND.n737 585
R840 VGND.n1018 VGND.n738 585
R841 VGND.n816 VGND.n775 585
R842 VGND.n815 VGND.n814 585
R843 VGND.n806 VGND.n805 585
R844 VGND.n804 VGND.n803 585
R845 VGND.n798 VGND.n797 585
R846 VGND.n796 VGND.n795 585
R847 VGND.n790 VGND.n755 585
R848 VGND.n1011 VGND.n1010 585
R849 VGND.n1014 VGND.n1013 585
R850 VGND.n999 VGND.n746 585
R851 VGND.n1970 VGND.n73 585
R852 VGND.n76 VGND.n73 585
R853 VGND.n823 VGND.n822 585
R854 VGND.n858 VGND.n857 585
R855 VGND.n830 VGND.n829 585
R856 VGND.n851 VGND.n850 585
R857 VGND.n849 VGND.n848 585
R858 VGND.n847 VGND.n834 585
R859 VGND.n833 VGND.n832 585
R860 VGND.n841 VGND.n840 585
R861 VGND.n839 VGND.n838 585
R862 VGND.n824 VGND.n74 585
R863 VGND.n1970 VGND.n1969 585
R864 VGND.n1969 VGND.n1968 585
R865 VGND.n835 VGND.n74 585
R866 VGND.n838 VGND.n837 585
R867 VGND.n842 VGND.n841 585
R868 VGND.n844 VGND.n832 585
R869 VGND.n847 VGND.n846 585
R870 VGND.n848 VGND.n831 585
R871 VGND.n852 VGND.n851 585
R872 VGND.n854 VGND.n830 585
R873 VGND.n857 VGND.n856 585
R874 VGND.n822 VGND.n821 585
R875 VGND.n1972 VGND.n71 585
R876 VGND.n71 VGND.n70 585
R877 VGND.n1974 VGND.n1973 585
R878 VGND.n1975 VGND.n1974 585
R879 VGND.n68 VGND.n67 585
R880 VGND.n1976 VGND.n68 585
R881 VGND.n1979 VGND.n1978 585
R882 VGND.n1978 VGND.n1977 585
R883 VGND.n1980 VGND.n66 585
R884 VGND.n69 VGND.n66 585
R885 VGND.n1982 VGND.n1981 585
R886 VGND.n1983 VGND.n1982 585
R887 VGND.n65 VGND.n64 585
R888 VGND.n1984 VGND.n65 585
R889 VGND.n1987 VGND.n1986 585
R890 VGND.n1986 VGND.n1985 585
R891 VGND.n1988 VGND.n62 585
R892 VGND.n62 VGND.n61 585
R893 VGND.n1990 VGND.n1989 585
R894 VGND.n1991 VGND.n1990 585
R895 VGND.n60 VGND.n59 585
R896 VGND.n1992 VGND.n60 585
R897 VGND.n1995 VGND.n1994 585
R898 VGND.n1994 VGND.n1993 585
R899 VGND.n1998 VGND.n1997 585
R900 VGND.n1999 VGND.n1998 585
R901 VGND.n1997 VGND.n1996 585
R902 VGND.n43 VGND.n42 585
R903 VGND.n45 VGND.n44 585
R904 VGND.n36 VGND.n34 585
R905 VGND.n2002 VGND.n2001 585
R906 VGND.n37 VGND.n35 585
R907 VGND.n1020 VGND.n1019 585
R908 VGND.n1019 VGND.n1018 585
R909 VGND.n1022 VGND.n1021 585
R910 VGND.n1021 VGND.n38 585
R911 VGND.n749 VGND.n748 585
R912 VGND.n750 VGND.n747 585
R913 VGND.n752 VGND.n751 585
R914 VGND.n1024 VGND.n1023 585
R915 VGND.n1026 VGND.n734 585
R916 VGND.n1029 VGND.n1028 585
R917 VGND.n1030 VGND.n733 585
R918 VGND.n1033 VGND.n1032 585
R919 VGND.n1035 VGND.n732 585
R920 VGND.n1038 VGND.n1037 585
R921 VGND.n1039 VGND.n731 585
R922 VGND.n1041 VGND.n1040 585
R923 VGND.n1043 VGND.n730 585
R924 VGND.n1046 VGND.n1045 585
R925 VGND.n1047 VGND.n729 585
R926 VGND.n1049 VGND.n1048 585
R927 VGND.n1879 VGND.n1878 585
R928 VGND.n1878 VGND.n1877 585
R929 VGND.n1876 VGND.n1867 585
R930 VGND.n1875 VGND.n1874 585
R931 VGND.n1873 VGND.n1872 585
R932 VGND.n1871 VGND.n1870 585
R933 VGND.n1869 VGND.n1868 585
R934 VGND.n191 VGND.n190 585
R935 VGND.n189 VGND.n188 585
R936 VGND.n186 VGND.n184 585
R937 VGND.n1169 VGND.n55 585
R938 VGND.n1999 VGND.n55 585
R939 VGND.n1171 VGND.n1170 585
R940 VGND.n1173 VGND.n1172 585
R941 VGND.n1175 VGND.n1174 585
R942 VGND.n1271 VGND.n1270 585
R943 VGND.n1269 VGND.n1268 585
R944 VGND.n1267 VGND.n1266 585
R945 VGND.n1265 VGND.n1264 585
R946 VGND.n1263 VGND.n1262 585
R947 VGND.n1261 VGND.n1260 585
R948 VGND.n1259 VGND.n1258 585
R949 VGND.n1255 VGND.n54 585
R950 VGND.n1999 VGND.n54 585
R951 VGND.n1168 VGND.n48 585
R952 VGND.n1999 VGND.n48 585
R953 VGND.n1167 VGND.n1166 585
R954 VGND.n727 VGND.n698 585
R955 VGND.n1162 VGND.n1161 585
R956 VGND.n1061 VGND.n703 585
R957 VGND.n1067 VGND.n1066 585
R958 VGND.n1058 VGND.n1057 585
R959 VGND.n1060 VGND.n1059 585
R960 VGND.n1082 VGND.n1081 585
R961 VGND.n1080 VGND.n1056 585
R962 VGND.n1146 VGND.n1145 585
R963 VGND.n1144 VGND.n1143 585
R964 VGND.n1880 VGND.n1879 585
R965 VGND.n1881 VGND.n1880 585
R966 VGND.n1882 VGND.n183 585
R967 VGND.n1787 VGND.n227 585
R968 VGND.n1786 VGND.n1785 585
R969 VGND.n244 VGND.n242 585
R970 VGND.n1860 VGND.n203 585
R971 VGND.n1860 VGND.n1859 585
R972 VGND.n1848 VGND.n202 585
R973 VGND.n1858 VGND.n202 585
R974 VGND.n1856 VGND.n1855 585
R975 VGND.n1857 VGND.n1856 585
R976 VGND.n231 VGND.n205 585
R977 VGND.n205 VGND.n204 585
R978 VGND.n233 VGND.n230 585
R979 VGND.n230 VGND.n229 585
R980 VGND.n240 VGND.n239 585
R981 VGND.n241 VGND.n240 585
R982 VGND.n1790 VGND.n1789 585
R983 VGND.n1789 VGND.n1788 585
R984 VGND.n1861 VGND.n181 585
R985 VGND.n1862 VGND.n1861 585
R986 VGND.n1885 VGND.n1884 585
R987 VGND.n1884 VGND.n1883 585
R988 VGND.n158 VGND.n157 585
R989 VGND.n1910 VGND.n158 585
R990 VGND.n163 VGND.n159 585
R991 VGND.n1909 VGND.n159 585
R992 VGND.n1906 VGND.n160 585
R993 VGND.n1908 VGND.n160 585
R994 VGND.n1905 VGND.n164 585
R995 VGND.n164 VGND.n161 585
R996 VGND.n1904 VGND.n165 585
R997 VGND.n1902 VGND.n165 585
R998 VGND.n1900 VGND.n166 585
R999 VGND.n1901 VGND.n1900 585
R1000 VGND.n1899 VGND.n169 585
R1001 VGND.n1899 VGND.n1898 585
R1002 VGND.n1895 VGND.n168 585
R1003 VGND.n170 VGND.n168 585
R1004 VGND.n1894 VGND.n172 585
R1005 VGND.n176 VGND.n172 585
R1006 VGND.n1893 VGND.n173 585
R1007 VGND.n1891 VGND.n173 585
R1008 VGND.n177 VGND.n174 585
R1009 VGND.n1890 VGND.n177 585
R1010 VGND.n1887 VGND.n178 585
R1011 VGND.n1889 VGND.n178 585
R1012 VGND.n1888 VGND.n1887 585
R1013 VGND.n1889 VGND.n1888 585
R1014 VGND.n175 VGND.n174 585
R1015 VGND.n1890 VGND.n175 585
R1016 VGND.n1893 VGND.n1892 585
R1017 VGND.n1892 VGND.n1891 585
R1018 VGND.n1894 VGND.n171 585
R1019 VGND.n176 VGND.n171 585
R1020 VGND.n1896 VGND.n1895 585
R1021 VGND.n1896 VGND.n170 585
R1022 VGND.n1897 VGND.n169 585
R1023 VGND.n1898 VGND.n1897 585
R1024 VGND.n167 VGND.n166 585
R1025 VGND.n1901 VGND.n167 585
R1026 VGND.n1904 VGND.n1903 585
R1027 VGND.n1903 VGND.n1902 585
R1028 VGND.n1905 VGND.n162 585
R1029 VGND.n162 VGND.n161 585
R1030 VGND.n1907 VGND.n1906 585
R1031 VGND.n1908 VGND.n1907 585
R1032 VGND.n163 VGND.n156 585
R1033 VGND.n1909 VGND.n156 585
R1034 VGND.n1911 VGND.n157 585
R1035 VGND.n1911 VGND.n1910 585
R1036 VGND.n673 VGND.n672 585
R1037 VGND.n672 VGND.n116 585
R1038 VGND.n670 VGND.n663 585
R1039 VGND.n1914 VGND.n1913 585
R1040 VGND.n1913 VGND.n1912 585
R1041 VGND.n155 VGND.n151 585
R1042 VGND.n1916 VGND.n1915 585
R1043 VGND.n1141 VGND.n150 585
R1044 VGND.n669 VGND.n667 585
R1045 VGND.n675 VGND.n674 585
R1046 VGND.n1918 VGND.n149 585
R1047 VGND.n1920 VGND.n1919 585
R1048 VGND.n147 VGND.n122 585
R1049 VGND.n146 VGND.n145 585
R1050 VGND.n137 VGND.n125 585
R1051 VGND.n139 VGND.n138 585
R1052 VGND.n135 VGND.n134 585
R1053 VGND.n130 VGND.n128 585
R1054 VGND.n112 VGND.n111 585
R1055 VGND.n1930 VGND.n1929 585
R1056 VGND.n1933 VGND.n1932 585
R1057 VGND.n1925 VGND.n108 585
R1058 VGND.n1928 VGND.n1927 585
R1059 VGND.n129 VGND.n113 585
R1060 VGND.n133 VGND.n132 585
R1061 VGND.n131 VGND.n126 585
R1062 VGND.n141 VGND.n140 585
R1063 VGND.n143 VGND.n142 585
R1064 VGND.n144 VGND.n121 585
R1065 VGND.n1922 VGND.n1921 585
R1066 VGND.n123 VGND.n120 585
R1067 VGND.n153 VGND.n152 585
R1068 VGND.n109 VGND.n107 585
R1069 VGND.n109 VGND.n103 585
R1070 VGND.n872 VGND.n871 585
R1071 VGND.n1935 VGND.n1934 585
R1072 VGND.n1936 VGND.n1935 585
R1073 VGND.n861 VGND.n819 585
R1074 VGND.n864 VGND.n863 585
R1075 VGND.n865 VGND.n864 585
R1076 VGND.n867 VGND.n819 585
R1077 VGND.n869 VGND.n868 585
R1078 VGND.n461 VGND.n458 585
R1079 VGND.n1677 VGND.n1676 585
R1080 VGND.n1680 VGND.n1679 585
R1081 VGND.n457 VGND.n448 585
R1082 VGND.n447 VGND.n443 585
R1083 VGND.n1691 VGND.n1690 585
R1084 VGND.n1693 VGND.n442 585
R1085 VGND.n1694 VGND.n308 585
R1086 VGND.n1697 VGND.n1696 585
R1087 VGND.n944 VGND.n313 585
R1088 VGND.n1673 VGND.n1672 585
R1089 VGND.n1675 VGND.n1674 585
R1090 VGND.n455 VGND.n454 585
R1091 VGND.n453 VGND.n452 585
R1092 VGND.n1687 VGND.n1686 585
R1093 VGND.n1689 VGND.n1688 585
R1094 VGND.n444 VGND.n307 585
R1095 VGND.n1705 VGND.n1704 585
R1096 VGND.n1698 VGND.n306 585
R1097 VGND.n943 VGND.n942 585
R1098 VGND.n1783 VGND.n1782 557.284
R1099 VGND.n10 VGND.n9 540.958
R1100 VGND.n1353 VGND.n542 523.662
R1101 VGND.n482 VGND.n289 514.894
R1102 VGND.n1756 VGND.n1755 514.894
R1103 VGND.n1557 VGND.t34 474.312
R1104 VGND.n1755 VGND.n1754 452.726
R1105 VGND.n2 VGND.t34 149.661
R1106 VGND.n1658 VGND.n542 448.981
R1107 VGND.n228 VGND.n199 446.976
R1108 VGND.n1924 VGND.n114 445.986
R1109 VGND.t16 VGND.t27 443.082
R1110 VGND.n1912 VGND.t34 442.993
R1111 VGND.n1548 VGND.t34 433.945
R1112 VGND.n1506 VGND.t34 425.445
R1113 VGND.n63 VGND.n31 416
R1114 VGND.t30 VGND.t23 396.397
R1115 VGND.t41 VGND.t7 392.289
R1116 VGND.n1910 VGND.n114 369.911
R1117 VGND.n18 VGND.n13 368.589
R1118 VGND.t11 VGND.t12 364.498
R1119 VGND.t10 VGND.t11 364.498
R1120 VGND.t9 VGND.t10 364.498
R1121 VGND.t8 VGND.t9 364.498
R1122 VGND.t7 VGND.t8 364.498
R1123 VGND.n1943 VGND.n1942 361.087
R1124 VGND.n1968 VGND.n77 358.697
R1125 VGND.n1942 VGND.n91 358.697
R1126 VGND.t13 VGND.t16 351.26
R1127 VGND.n2016 VGND.t15 338.911
R1128 VGND.t5 VGND.n76 330
R1129 VGND.n1941 VGND.t36 327.661
R1130 VGND.n820 VGND.t36 327.661
R1131 VGND.t34 VGND.n265 327.661
R1132 VGND.t29 VGND.t13 324.762
R1133 VGND.n1515 VGND.t34 324.683
R1134 VGND.n289 VGND.t36 323.404
R1135 VGND.n92 VGND.t36 323.404
R1136 VGND.n860 VGND.t36 323.404
R1137 VGND.n1329 VGND.n3 214.464
R1138 VGND.t34 VGND.n1756 323.404
R1139 VGND.n2020 VGND.n9 295.945
R1140 VGND.n483 VGND.n482 289.349
R1141 VGND.t24 VGND.n179 285.824
R1142 VGND.n1368 VGND.n262 284.928
R1143 VGND.n1901 VGND.t41 282.301
R1144 VGND.n1419 VGND.n262 281.55
R1145 VGND.n1784 VGND.n1783 261.099
R1146 VGND.n1218 VGND.n1183 258.334
R1147 VGND.n950 VGND.n774 258.334
R1148 VGND.n1769 VGND.n257 258.334
R1149 VGND.n1583 VGND.n1582 258.334
R1150 VGND.n407 VGND.n406 258.334
R1151 VGND.n1295 VGND.n1294 258.334
R1152 VGND.n1139 VGND.n1138 258.334
R1153 VGND.n1795 VGND.n1794 258.334
R1154 VGND.n890 VGND.n889 258.334
R1155 VGND.n1940 VGND.n99 257.466
R1156 VGND.n1648 VGND.n1647 257.466
R1157 VGND.n868 VGND.n867 257.466
R1158 VGND.n675 VGND.n667 257.466
R1159 VGND.n1049 VGND.n729 257.466
R1160 VGND.n752 VGND.n747 257.466
R1161 VGND.n1878 VGND.n54 257.466
R1162 VGND.t0 VGND.n542 254.529
R1163 VGND.n441 VGND.n319 254.34
R1164 VGND.n441 VGND.n318 254.34
R1165 VGND.n441 VGND.n317 254.34
R1166 VGND.n441 VGND.n316 254.34
R1167 VGND.n441 VGND.n315 254.34
R1168 VGND.n1707 VGND.n301 254.34
R1169 VGND.n1707 VGND.n300 254.34
R1170 VGND.n1707 VGND.n299 254.34
R1171 VGND.n1707 VGND.n298 254.34
R1172 VGND.n1707 VGND.n297 254.34
R1173 VGND.n1302 VGND.n679 254.34
R1174 VGND.n1302 VGND.n678 254.34
R1175 VGND.n1302 VGND.n677 254.34
R1176 VGND.n1302 VGND.n676 254.34
R1177 VGND.n1316 VGND.n587 254.34
R1178 VGND.n1316 VGND.n1315 254.34
R1179 VGND.n1316 VGND.n590 254.34
R1180 VGND.n1316 VGND.n589 254.34
R1181 VGND.n1316 VGND.n588 254.34
R1182 VGND.n1317 VGND.n1316 254.34
R1183 VGND.n558 VGND.n265 254.34
R1184 VGND.n1334 VGND.n265 254.34
R1185 VGND.n1337 VGND.n265 254.34
R1186 VGND.n1343 VGND.n265 254.34
R1187 VGND.n1346 VGND.n265 254.34
R1188 VGND.n1349 VGND.n1329 254.34
R1189 VGND.n1451 VGND.n1329 254.34
R1190 VGND.n1340 VGND.n1329 254.34
R1191 VGND.n1458 VGND.n1329 254.34
R1192 VGND.n1461 VGND.n1329 254.34
R1193 VGND.n1326 VGND.n1325 254.34
R1194 VGND.n1302 VGND.n1301 254.34
R1195 VGND.n1658 VGND.n543 254.34
R1196 VGND.n1326 VGND.n582 254.34
R1197 VGND.n1326 VGND.n581 254.34
R1198 VGND.n1326 VGND.n563 254.34
R1199 VGND.n1326 VGND.n562 254.34
R1200 VGND.n1326 VGND.n561 254.34
R1201 VGND.n1659 VGND.n1658 254.34
R1202 VGND.n1658 VGND.n545 254.34
R1203 VGND.n1658 VGND.n546 254.34
R1204 VGND.n1658 VGND.n547 254.34
R1205 VGND.n1658 VGND.n1657 254.34
R1206 VGND.n1668 VGND.n441 254.34
R1207 VGND.n1664 VGND.n1663 254.34
R1208 VGND.n538 VGND.n92 254.34
R1209 VGND.n1707 VGND.n296 254.34
R1210 VGND.n1939 VGND.n1938 254.34
R1211 VGND.n1941 VGND.n98 254.34
R1212 VGND.n530 VGND.n92 254.34
R1213 VGND.n528 VGND.n92 254.34
R1214 VGND.n518 VGND.n92 254.34
R1215 VGND.n516 VGND.n92 254.34
R1216 VGND.n1941 VGND.n97 254.34
R1217 VGND.n1941 VGND.n96 254.34
R1218 VGND.n1941 VGND.n95 254.34
R1219 VGND.n1941 VGND.n94 254.34
R1220 VGND.n294 VGND.n289 254.34
R1221 VGND.n1718 VGND.n289 254.34
R1222 VGND.n1721 VGND.n289 254.34
R1223 VGND.n1725 VGND.n289 254.34
R1224 VGND.n1728 VGND.n289 254.34
R1225 VGND.n1711 VGND.n289 254.34
R1226 VGND.n1756 VGND.n271 254.34
R1227 VGND.n1756 VGND.n270 254.34
R1228 VGND.n1756 VGND.n269 254.34
R1229 VGND.n1756 VGND.n268 254.34
R1230 VGND.n1756 VGND.n267 254.34
R1231 VGND.n1756 VGND.n266 254.34
R1232 VGND.n1150 VGND.n1149 254.34
R1233 VGND.n1150 VGND.n1053 254.34
R1234 VGND.n1150 VGND.n1052 254.34
R1235 VGND.n1150 VGND.n1051 254.34
R1236 VGND.n1018 VGND.n739 254.34
R1237 VGND.n1018 VGND.n740 254.34
R1238 VGND.n1018 VGND.n741 254.34
R1239 VGND.n1018 VGND.n742 254.34
R1240 VGND.n1018 VGND.n1017 254.34
R1241 VGND.n817 VGND.n754 254.34
R1242 VGND.n776 VGND.n754 254.34
R1243 VGND.n779 VGND.n754 254.34
R1244 VGND.n789 VGND.n754 254.34
R1245 VGND.n1012 VGND.n754 254.34
R1246 VGND.n754 VGND.n753 254.34
R1247 VGND.n860 VGND.n859 254.34
R1248 VGND.n860 VGND.n828 254.34
R1249 VGND.n860 VGND.n827 254.34
R1250 VGND.n860 VGND.n826 254.34
R1251 VGND.n860 VGND.n825 254.34
R1252 VGND.n836 VGND.n820 254.34
R1253 VGND.n843 VGND.n820 254.34
R1254 VGND.n845 VGND.n820 254.34
R1255 VGND.n853 VGND.n820 254.34
R1256 VGND.n855 VGND.n820 254.34
R1257 VGND.n1999 VGND.n39 254.34
R1258 VGND.n1997 VGND.n58 254.34
R1259 VGND.n1999 VGND.n40 254.34
R1260 VGND.n1997 VGND.n57 254.34
R1261 VGND.n1999 VGND.n41 254.34
R1262 VGND.n1999 VGND.n46 254.34
R1263 VGND.n2000 VGND.n1999 254.34
R1264 VGND.n1999 VGND.n47 254.34
R1265 VGND.n1025 VGND.n38 254.34
R1266 VGND.n1027 VGND.n38 254.34
R1267 VGND.n1034 VGND.n38 254.34
R1268 VGND.n1036 VGND.n38 254.34
R1269 VGND.n1042 VGND.n38 254.34
R1270 VGND.n1044 VGND.n38 254.34
R1271 VGND.n1151 VGND.n1150 254.34
R1272 VGND.n1879 VGND.n194 254.34
R1273 VGND.n1879 VGND.n193 254.34
R1274 VGND.n1879 VGND.n192 254.34
R1275 VGND.n1879 VGND.n187 254.34
R1276 VGND.n1999 VGND.n49 254.34
R1277 VGND.n1999 VGND.n50 254.34
R1278 VGND.n1999 VGND.n51 254.34
R1279 VGND.n1999 VGND.n52 254.34
R1280 VGND.n1999 VGND.n53 254.34
R1281 VGND.n1165 VGND.n1164 254.34
R1282 VGND.n1164 VGND.n1163 254.34
R1283 VGND.n1164 VGND.n702 254.34
R1284 VGND.n1164 VGND.n701 254.34
R1285 VGND.n1164 VGND.n700 254.34
R1286 VGND.n1164 VGND.n699 254.34
R1287 VGND.n1917 VGND.n110 254.34
R1288 VGND.n1150 VGND.n1050 254.34
R1289 VGND.n1924 VGND.n115 254.34
R1290 VGND.n1303 VGND.n1302 254.34
R1291 VGND.n148 VGND.n110 254.34
R1292 VGND.n124 VGND.n110 254.34
R1293 VGND.n136 VGND.n110 254.34
R1294 VGND.n127 VGND.n110 254.34
R1295 VGND.n1931 VGND.n110 254.34
R1296 VGND.n1926 VGND.n1924 254.34
R1297 VGND.n1924 VGND.n117 254.34
R1298 VGND.n1924 VGND.n118 254.34
R1299 VGND.n1924 VGND.n119 254.34
R1300 VGND.n1924 VGND.n1923 254.34
R1301 VGND.n870 VGND.n441 254.34
R1302 VGND.n862 VGND.n860 254.34
R1303 VGND.n866 VGND.n820 254.34
R1304 VGND.n1707 VGND.n302 254.34
R1305 VGND.n1678 VGND.n441 254.34
R1306 VGND.n456 VGND.n441 254.34
R1307 VGND.n1692 VGND.n441 254.34
R1308 VGND.n1695 VGND.n441 254.34
R1309 VGND.n1707 VGND.n303 254.34
R1310 VGND.n1707 VGND.n304 254.34
R1311 VGND.n1707 VGND.n305 254.34
R1312 VGND.n1707 VGND.n1706 254.34
R1313 VGND.n1710 VGND.n1708 251.614
R1314 VGND.n1753 VGND.n274 251.614
R1315 VGND.n1530 VGND.n1529 251.614
R1316 VGND.n1666 VGND.n1665 251.614
R1317 VGND.n1324 VGND.n583 251.614
R1318 VGND.n1916 VGND.n150 251.614
R1319 VGND.n861 VGND.n818 251.614
R1320 VGND.n1252 VGND.n1251 250
R1321 VGND.n1257 VGND.n1177 245.638
R1322 VGND.n1646 VGND.t34 242.202
R1323 VGND.n1968 VGND.n1967 241.523
R1324 VGND.n507 VGND.n91 241.523
R1325 VGND.n1441 VGND.n1440 239.924
R1326 VGND.n1257 VGND.n1176 234.006
R1327 VGND.n1658 VGND.t34 230.476
R1328 VGND.n76 VGND.n70 229.565
R1329 VGND.n484 VGND.n483 229.565
R1330 VGND.n1326 VGND.n2 1.99647
R1331 VGND.n110 VGND.t41 227.483
R1332 VGND.t34 VGND.n116 224.49
R1333 VGND.n1811 VGND.n1809 221.667
R1334 VGND VGND.t17 219.8
R1335 VGND VGND.t28 219.8
R1336 VGND.n754 VGND.t36 216.657
R1337 VGND.n1150 VGND.t41 216.657
R1338 VGND.n1993 VGND.n1992 215.218
R1339 VGND.n1992 VGND.n1991 215.218
R1340 VGND.n1991 VGND.n61 215.218
R1341 VGND.n1985 VGND.n61 215.218
R1342 VGND.n1985 VGND.n1984 215.218
R1343 VGND.n1977 VGND.n69 215.218
R1344 VGND.n1977 VGND.n1976 215.218
R1345 VGND.n1976 VGND.n1975 215.218
R1346 VGND.n1975 VGND.n70 215.218
R1347 VGND.n1967 VGND.n78 215.218
R1348 VGND.n82 VGND.n78 215.218
R1349 VGND.n1960 VGND.n82 215.218
R1350 VGND.n1960 VGND.n1959 215.218
R1351 VGND.n1952 VGND.n86 215.218
R1352 VGND.n1952 VGND.n1951 215.218
R1353 VGND.n1951 VGND.n1950 215.218
R1354 VGND.n1950 VGND.n87 215.218
R1355 VGND.n1944 VGND.n87 215.218
R1356 VGND.n507 VGND.n506 215.218
R1357 VGND.n506 VGND.n505 215.218
R1358 VGND.n499 VGND.n477 215.218
R1359 VGND.n499 VGND.n498 215.218
R1360 VGND.n497 VGND.n478 215.218
R1361 VGND.n491 VGND.n478 215.218
R1362 VGND.n491 VGND.n490 215.218
R1363 VGND.n489 VGND.n484 215.218
R1364 VGND.n1302 VGND.t34 213.57
R1365 VGND.t15 VGND.t29 206.444
R1366 VGND.n441 VGND.t36 206.107
R1367 VGND VGND.t14 202.4
R1368 VGND.n509 VGND.n508 195.049
R1369 VGND.n1467 VGND.n1466 195.049
R1370 VGND.n440 VGND.n102 195.049
R1371 VGND.n1966 VGND.n75 195.049
R1372 VGND.n871 VGND.n106 195.049
R1373 VGND.n671 VGND.n670 195.049
R1374 VGND.n1437 VGND.n1350 195.049
R1375 VGND.n1019 VGND.n735 195.049
R1376 VGND.n1994 VGND.n56 195.049
R1377 VGND.n1166 VGND.n697 195.049
R1378 VGND.n1859 VGND.n1858 187.768
R1379 VGND.n1857 VGND.n204 187.768
R1380 VGND.n229 VGND.n204 187.768
R1381 VGND.n1788 VGND.n241 187.768
R1382 VGND.n1788 VGND.n1787 187.768
R1383 VGND.n1787 VGND.n1786 187.768
R1384 VGND.n1786 VGND.n242 187.768
R1385 VGND.n1441 VGND.n242 187.768
R1386 VGND.n1431 VGND.n1353 187.768
R1387 VGND.n1431 VGND.n1430 187.768
R1388 VGND.n1430 VGND.n1429 187.768
R1389 VGND.n1429 VGND.n264 187.768
R1390 VGND.n1757 VGND.n264 187.768
R1391 VGND.n1775 VGND.n251 187.768
R1392 VGND.n1775 VGND.n1774 187.768
R1393 VGND.n1774 VGND.n1773 187.768
R1394 VGND.n1773 VGND.n252 187.768
R1395 VGND.n1754 VGND.n252 187.768
R1396 VGND.n1877 VGND.n1876 187.768
R1397 VGND.n1876 VGND.n1875 187.768
R1398 VGND.n1875 VGND.n1872 187.768
R1399 VGND.n1872 VGND.n1871 187.768
R1400 VGND.n1871 VGND.n1868 187.768
R1401 VGND.n190 VGND.n189 187.768
R1402 VGND.n189 VGND.n184 187.768
R1403 VGND.n1881 VGND.n184 187.768
R1404 VGND.n1882 VGND.n1881 187.768
R1405 VGND.n1883 VGND.n1882 187.768
R1406 VGND.n485 VGND.n288 187.249
R1407 VGND.n1576 VGND.n1575 187.249
R1408 VGND.n314 VGND.n104 187.249
R1409 VGND.n1945 VGND.n90 187.249
R1410 VGND.n1669 VGND.n105 187.249
R1411 VGND.n1327 VGND.n560 187.249
R1412 VGND.n738 VGND.n109 187.249
R1413 VGND.n73 VGND.n71 187.249
R1414 VGND.n1913 VGND.n155 187.249
R1415 VGND.n1183 VGND.n1182 185
R1416 VGND.n1219 VGND.n1218 185
R1417 VGND.n1221 VGND.n1220 185
R1418 VGND.n1223 VGND.n1222 185
R1419 VGND.n1225 VGND.n1224 185
R1420 VGND.n1227 VGND.n1226 185
R1421 VGND.n1229 VGND.n1228 185
R1422 VGND.n1231 VGND.n1230 185
R1423 VGND.n1233 VGND.n1232 185
R1424 VGND.n1235 VGND.n1234 185
R1425 VGND.n1237 VGND.n1236 185
R1426 VGND.n1239 VGND.n1238 185
R1427 VGND.n1241 VGND.n1240 185
R1428 VGND.n1243 VGND.n1242 185
R1429 VGND.n1245 VGND.n1244 185
R1430 VGND.n1247 VGND.n1246 185
R1431 VGND.n1248 VGND.n1200 185
R1432 VGND.n1250 VGND.n1249 185
R1433 VGND.t44 VGND.n1250 185
R1434 VGND.n1217 VGND.n1199 185
R1435 VGND.n1216 VGND.n1215 185
R1436 VGND.n1214 VGND.n1213 185
R1437 VGND.n1212 VGND.n1211 185
R1438 VGND.n1210 VGND.n1209 185
R1439 VGND.n1208 VGND.n1207 185
R1440 VGND.n1206 VGND.n1205 185
R1441 VGND.n1204 VGND.n1203 185
R1442 VGND.n1202 VGND.n1201 185
R1443 VGND.n1251 VGND.n1176 185
R1444 VGND.n984 VGND.n983 185
R1445 VGND.n986 VGND.n762 185
R1446 VGND.n989 VGND.n988 185
R1447 VGND.n990 VGND.n761 185
R1448 VGND.n992 VGND.n991 185
R1449 VGND.n994 VGND.n760 185
R1450 VGND.n997 VGND.n996 185
R1451 VGND.n998 VGND.n759 185
R1452 VGND.n1003 VGND.n1002 185
R1453 VGND.n966 VGND.n767 185
R1454 VGND.n968 VGND.n967 185
R1455 VGND.n970 VGND.n969 185
R1456 VGND.n973 VGND.n972 185
R1457 VGND.n974 VGND.n765 185
R1458 VGND.n976 VGND.n975 185
R1459 VGND.n978 VGND.n764 185
R1460 VGND.n981 VGND.n980 185
R1461 VGND.n982 VGND.n763 185
R1462 VGND.n950 VGND.n949 185
R1463 VGND.n952 VGND.n772 185
R1464 VGND.n954 VGND.n953 185
R1465 VGND.n955 VGND.n771 185
R1466 VGND.n957 VGND.n956 185
R1467 VGND.n959 VGND.n769 185
R1468 VGND.n961 VGND.n960 185
R1469 VGND.n962 VGND.n768 185
R1470 VGND.n964 VGND.n963 185
R1471 VGND.n813 VGND.n774 185
R1472 VGND.n782 VGND.n777 185
R1473 VGND.n783 VGND.n778 185
R1474 VGND.n785 VGND.n780 185
R1475 VGND.n788 VGND.n787 185
R1476 VGND.n791 VGND.n758 185
R1477 VGND.n1009 VGND.n1008 185
R1478 VGND.n1006 VGND.n745 185
R1479 VGND.n1005 VGND.n744 185
R1480 VGND.n1404 VGND.n1403 185
R1481 VGND.n1406 VGND.n1358 185
R1482 VGND.n1409 VGND.n1408 185
R1483 VGND.n1410 VGND.n1357 185
R1484 VGND.n1412 VGND.n1411 185
R1485 VGND.n1414 VGND.n1356 185
R1486 VGND.n1417 VGND.n1416 185
R1487 VGND.n1418 VGND.n1355 185
R1488 VGND.n1420 VGND.n1419 185
R1489 VGND.n1386 VGND.n1363 185
R1490 VGND.n1388 VGND.n1387 185
R1491 VGND.n1390 VGND.n1389 185
R1492 VGND.n1393 VGND.n1392 185
R1493 VGND.n1394 VGND.n1361 185
R1494 VGND.n1396 VGND.n1395 185
R1495 VGND.n1398 VGND.n1360 185
R1496 VGND.n1401 VGND.n1400 185
R1497 VGND.n1402 VGND.n1359 185
R1498 VGND.n1368 VGND.n257 185
R1499 VGND.n1372 VGND.n1369 185
R1500 VGND.n1374 VGND.n1373 185
R1501 VGND.n1375 VGND.n1367 185
R1502 VGND.n1377 VGND.n1376 185
R1503 VGND.n1379 VGND.n1365 185
R1504 VGND.n1381 VGND.n1380 185
R1505 VGND.n1382 VGND.n1364 185
R1506 VGND.n1384 VGND.n1383 185
R1507 VGND.n1620 VGND.n1619 185
R1508 VGND.n1622 VGND.n1621 185
R1509 VGND.n1624 VGND.n1623 185
R1510 VGND.n1626 VGND.n1625 185
R1511 VGND.n1628 VGND.n1627 185
R1512 VGND.n1630 VGND.n1629 185
R1513 VGND.n1632 VGND.n1631 185
R1514 VGND.n1633 VGND.n1492 185
R1515 VGND.n1637 VGND.n1636 185
R1516 VGND.n1602 VGND.n1601 185
R1517 VGND.n1604 VGND.n1603 185
R1518 VGND.n1606 VGND.n1605 185
R1519 VGND.n1608 VGND.n1607 185
R1520 VGND.n1610 VGND.n1609 185
R1521 VGND.n1612 VGND.n1611 185
R1522 VGND.n1614 VGND.n1613 185
R1523 VGND.n1616 VGND.n1615 185
R1524 VGND.n1618 VGND.n1617 185
R1525 VGND.n1584 VGND.n1583 185
R1526 VGND.n1586 VGND.n1585 185
R1527 VGND.n1588 VGND.n1587 185
R1528 VGND.n1590 VGND.n1589 185
R1529 VGND.n1592 VGND.n1591 185
R1530 VGND.n1594 VGND.n1593 185
R1531 VGND.n1596 VGND.n1595 185
R1532 VGND.n1598 VGND.n1597 185
R1533 VGND.n1600 VGND.n1599 185
R1534 VGND.n1582 VGND.n1581 185
R1535 VGND.n1536 VGND.n1535 185
R1536 VGND.n1534 VGND.n1533 185
R1537 VGND.n1554 VGND.n1553 185
R1538 VGND.n1552 VGND.n1551 185
R1539 VGND.n1541 VGND.n1540 185
R1540 VGND.n1544 VGND.n1475 185
R1541 VGND.n1641 VGND.n1640 185
R1542 VGND.n1474 VGND.n1472 185
R1543 VGND.n384 VGND.n353 185
R1544 VGND.n399 VGND.n398 185
R1545 VGND.n397 VGND.n354 185
R1546 VGND.n396 VGND.n395 185
R1547 VGND.n394 VGND.n393 185
R1548 VGND.n392 VGND.n391 185
R1549 VGND.n390 VGND.n389 185
R1550 VGND.n388 VGND.n387 185
R1551 VGND.n386 VGND.n385 185
R1552 VGND.n367 VGND.n366 185
R1553 VGND.n369 VGND.n368 185
R1554 VGND.n371 VGND.n370 185
R1555 VGND.n373 VGND.n372 185
R1556 VGND.n375 VGND.n374 185
R1557 VGND.n377 VGND.n376 185
R1558 VGND.n379 VGND.n378 185
R1559 VGND.n381 VGND.n380 185
R1560 VGND.n383 VGND.n382 185
R1561 VGND.n406 VGND.n405 185
R1562 VGND.n404 VGND.n403 185
R1563 VGND.n402 VGND.n341 185
R1564 VGND.n355 VGND.n342 185
R1565 VGND.n357 VGND.n356 185
R1566 VGND.n359 VGND.n358 185
R1567 VGND.n361 VGND.n360 185
R1568 VGND.n363 VGND.n362 185
R1569 VGND.n365 VGND.n364 185
R1570 VGND.n408 VGND.n407 185
R1571 VGND.n413 VGND.n412 185
R1572 VGND.n415 VGND.n414 185
R1573 VGND.n420 VGND.n419 185
R1574 VGND.n422 VGND.n421 185
R1575 VGND.n427 VGND.n426 185
R1576 VGND.n429 VGND.n428 185
R1577 VGND.n434 VGND.n433 185
R1578 VGND.n436 VGND.n435 185
R1579 VGND.n649 VGND.n648 185
R1580 VGND.n651 VGND.n650 185
R1581 VGND.n653 VGND.n652 185
R1582 VGND.n655 VGND.n654 185
R1583 VGND.n657 VGND.n656 185
R1584 VGND.n659 VGND.n658 185
R1585 VGND.n661 VGND.n660 185
R1586 VGND.n662 VGND.n613 185
R1587 VGND.n1308 VGND.n1307 185
R1588 VGND.n631 VGND.n630 185
R1589 VGND.n633 VGND.n632 185
R1590 VGND.n635 VGND.n634 185
R1591 VGND.n637 VGND.n636 185
R1592 VGND.n639 VGND.n638 185
R1593 VGND.n641 VGND.n640 185
R1594 VGND.n643 VGND.n642 185
R1595 VGND.n645 VGND.n644 185
R1596 VGND.n647 VGND.n646 185
R1597 VGND.n1294 VGND.n584 185
R1598 VGND.n615 VGND.n614 185
R1599 VGND.n617 VGND.n616 185
R1600 VGND.n619 VGND.n618 185
R1601 VGND.n621 VGND.n620 185
R1602 VGND.n623 VGND.n622 185
R1603 VGND.n625 VGND.n624 185
R1604 VGND.n627 VGND.n626 185
R1605 VGND.n629 VGND.n628 185
R1606 VGND.n1296 VGND.n1295 185
R1607 VGND.n1293 VGND.n1292 185
R1608 VGND.n1291 VGND.n1290 185
R1609 VGND.n1285 VGND.n1284 185
R1610 VGND.n1283 VGND.n1282 185
R1611 VGND.n1277 VGND.n1276 185
R1612 VGND.n689 VGND.n596 185
R1613 VGND.n1312 VGND.n1311 185
R1614 VGND.n664 VGND.n595 185
R1615 VGND.n1770 VGND.n1769 185
R1616 VGND.n1767 VGND.n255 185
R1617 VGND.n1766 VGND.n248 185
R1618 VGND.n1764 VGND.n247 185
R1619 VGND.n1763 VGND.n259 185
R1620 VGND.n1761 VGND.n1760 185
R1621 VGND.n1426 VGND.n260 185
R1622 VGND.n1425 VGND.n1424 185
R1623 VGND.n1422 VGND.n1351 185
R1624 VGND.n1103 VGND.n1102 185
R1625 VGND.n1101 VGND.n1100 185
R1626 VGND.n1099 VGND.n1098 185
R1627 VGND.n1097 VGND.n1096 185
R1628 VGND.n1095 VGND.n1094 185
R1629 VGND.n1093 VGND.n1092 185
R1630 VGND.n1091 VGND.n1090 185
R1631 VGND.n725 VGND.n724 185
R1632 VGND.n1156 VGND.n1155 185
R1633 VGND.n1121 VGND.n1120 185
R1634 VGND.n1119 VGND.n1118 185
R1635 VGND.n1117 VGND.n1116 185
R1636 VGND.n1115 VGND.n1114 185
R1637 VGND.n1113 VGND.n1112 185
R1638 VGND.n1111 VGND.n1110 185
R1639 VGND.n1109 VGND.n1108 185
R1640 VGND.n1107 VGND.n1106 185
R1641 VGND.n1105 VGND.n1104 185
R1642 VGND.n1140 VGND.n1139 185
R1643 VGND.n1137 VGND.n1136 185
R1644 VGND.n1135 VGND.n1134 185
R1645 VGND.n1133 VGND.n1132 185
R1646 VGND.n1131 VGND.n1130 185
R1647 VGND.n1129 VGND.n1128 185
R1648 VGND.n1127 VGND.n1126 185
R1649 VGND.n1125 VGND.n1124 185
R1650 VGND.n1123 VGND.n1122 185
R1651 VGND.n1138 VGND.n1088 185
R1652 VGND.n1087 VGND.n1086 185
R1653 VGND.n1085 VGND.n1084 185
R1654 VGND.n1077 VGND.n1076 185
R1655 VGND.n1075 VGND.n1074 185
R1656 VGND.n1069 VGND.n1068 185
R1657 VGND.n1062 VGND.n707 185
R1658 VGND.n1160 VGND.n1159 185
R1659 VGND.n726 VGND.n706 185
R1660 VGND.t44 VGND.n1252 185
R1661 VGND.n1829 VGND.n1828 185
R1662 VGND.n1831 VGND.n212 185
R1663 VGND.n1834 VGND.n1833 185
R1664 VGND.n1835 VGND.n211 185
R1665 VGND.n1837 VGND.n1836 185
R1666 VGND.n1839 VGND.n210 185
R1667 VGND.n1842 VGND.n1841 185
R1668 VGND.n1843 VGND.n209 185
R1669 VGND.n1846 VGND.n1845 185
R1670 VGND.n1812 VGND.n1811 185
R1671 VGND.n1813 VGND.n216 185
R1672 VGND.n1815 VGND.n1814 185
R1673 VGND.n1818 VGND.n1817 185
R1674 VGND.n1819 VGND.n215 185
R1675 VGND.n215 VGND.t43 185
R1676 VGND.n1821 VGND.n1820 185
R1677 VGND.n1823 VGND.n214 185
R1678 VGND.n1826 VGND.n1825 185
R1679 VGND.n1827 VGND.n213 185
R1680 VGND.n1796 VGND.n1795 185
R1681 VGND.n1797 VGND.n222 185
R1682 VGND.n1799 VGND.n1798 185
R1683 VGND.n1801 VGND.n220 185
R1684 VGND.n1803 VGND.n1802 185
R1685 VGND.n1804 VGND.n219 185
R1686 VGND.n1806 VGND.n1805 185
R1687 VGND.n1808 VGND.n218 185
R1688 VGND.n1809 VGND.n217 185
R1689 VGND.n1809 VGND.t43 185
R1690 VGND.n1794 VGND.n223 185
R1691 VGND.n238 VGND.n237 185
R1692 VGND.n236 VGND.n234 185
R1693 VGND.n232 VGND.n208 185
R1694 VGND.n1854 VGND.n1853 185
R1695 VGND.n1851 VGND.n206 185
R1696 VGND.n1850 VGND.n1849 185
R1697 VGND.n925 VGND.n924 185
R1698 VGND.n926 VGND.n876 185
R1699 VGND.n928 VGND.n927 185
R1700 VGND.n930 VGND.n875 185
R1701 VGND.n933 VGND.n932 185
R1702 VGND.n934 VGND.n874 185
R1703 VGND.n936 VGND.n935 185
R1704 VGND.n938 VGND.n873 185
R1705 VGND.n941 VGND.n940 185
R1706 VGND.n906 VGND.n881 185
R1707 VGND.n909 VGND.n908 185
R1708 VGND.n910 VGND.n880 185
R1709 VGND.n912 VGND.n911 185
R1710 VGND.n914 VGND.n879 185
R1711 VGND.n917 VGND.n916 185
R1712 VGND.n918 VGND.n878 185
R1713 VGND.n920 VGND.n919 185
R1714 VGND.n922 VGND.n877 185
R1715 VGND.n890 VGND.n462 185
R1716 VGND.n892 VGND.n886 185
R1717 VGND.n894 VGND.n893 185
R1718 VGND.n895 VGND.n885 185
R1719 VGND.n897 VGND.n896 185
R1720 VGND.n899 VGND.n883 185
R1721 VGND.n901 VGND.n900 185
R1722 VGND.n902 VGND.n882 185
R1723 VGND.n904 VGND.n903 185
R1724 VGND.n889 VGND.n460 185
R1725 VGND.n459 VGND.n451 185
R1726 VGND.n1682 VGND.n1681 185
R1727 VGND.n1685 VGND.n1684 185
R1728 VGND.n450 VGND.n446 185
R1729 VGND.n445 VGND.n310 185
R1730 VGND.n1703 VGND.n1702 185
R1731 VGND.n1700 VGND.n1699 185
R1732 VGND.n312 VGND.n311 185
R1733 VGND.n1861 VGND.n201 184.113
R1734 VGND.n1884 VGND.n180 178.589
R1735 VGND.n1858 VGND.t32 177.335
R1736 VGND.n513 VGND.n512 175.546
R1737 VGND.n522 VGND.n521 175.546
R1738 VGND.n525 VGND.n524 175.546
R1739 VGND.n532 VGND.n93 175.546
R1740 VGND.n535 VGND.n93 175.546
R1741 VGND.n508 VGND.n471 175.546
R1742 VGND.n504 VGND.n471 175.546
R1743 VGND.n504 VGND.n473 175.546
R1744 VGND.n500 VGND.n473 175.546
R1745 VGND.n500 VGND.n476 175.546
R1746 VGND.n496 VGND.n476 175.546
R1747 VGND.n496 VGND.n479 175.546
R1748 VGND.n492 VGND.n479 175.546
R1749 VGND.n492 VGND.n481 175.546
R1750 VGND.n488 VGND.n481 175.546
R1751 VGND.n488 VGND.n485 175.546
R1752 VGND.n1727 VGND.n1726 175.546
R1753 VGND.n1724 VGND.n1722 175.546
R1754 VGND.n1720 VGND.n1719 175.546
R1755 VGND.n1717 VGND.n292 175.546
R1756 VGND.n1713 VGND.n1712 175.546
R1757 VGND.n437 VGND.n99 175.546
R1758 VGND.n431 VGND.n430 175.546
R1759 VGND.n424 VGND.n423 175.546
R1760 VGND.n417 VGND.n416 175.546
R1761 VGND.n410 VGND.n409 175.546
R1762 VGND.n1708 VGND.n295 175.546
R1763 VGND.n1571 VGND.n1570 175.546
R1764 VGND.n1567 VGND.n1566 175.546
R1765 VGND.n1740 VGND.n1739 175.546
R1766 VGND.n1744 VGND.n1743 175.546
R1767 VGND.n1748 VGND.n1747 175.546
R1768 VGND.n1468 VGND.n1467 175.546
R1769 VGND.n1469 VGND.n1468 175.546
R1770 VGND.n1543 VGND.n1469 175.546
R1771 VGND.n1546 VGND.n1543 175.546
R1772 VGND.n1546 VGND.n1539 175.546
R1773 VGND.n1556 VGND.n1539 175.546
R1774 VGND.n1556 VGND.n1532 175.546
R1775 VGND.n1562 VGND.n1532 175.546
R1776 VGND.n1563 VGND.n1562 175.546
R1777 VGND.n1563 VGND.n1494 175.546
R1778 VGND.n1576 VGND.n1494 175.546
R1779 VGND.n1508 VGND.n1505 175.546
R1780 VGND.n1508 VGND.n1502 175.546
R1781 VGND.n1512 VGND.n1502 175.546
R1782 VGND.n1512 VGND.n1500 175.546
R1783 VGND.n1516 VGND.n1500 175.546
R1784 VGND.n1517 VGND.n1516 175.546
R1785 VGND.n1520 VGND.n1517 175.546
R1786 VGND.n1520 VGND.n1498 175.546
R1787 VGND.n1525 VGND.n1498 175.546
R1788 VGND.n1525 VGND.n1496 175.546
R1789 VGND.n1529 VGND.n1496 175.546
R1790 VGND.n1647 VGND.n557 175.546
R1791 VGND.n1643 VGND.n557 175.546
R1792 VGND.n1643 VGND.n1471 175.546
R1793 VGND.n1542 VGND.n1471 175.546
R1794 VGND.n1549 VGND.n1542 175.546
R1795 VGND.n1549 VGND.n1537 175.546
R1796 VGND.n1559 VGND.n1537 175.546
R1797 VGND.n1560 VGND.n1559 175.546
R1798 VGND.n1560 VGND.n1495 175.546
R1799 VGND.n1579 VGND.n1495 175.546
R1800 VGND.n1579 VGND.n1530 175.546
R1801 VGND.n567 VGND.n541 175.546
R1802 VGND.n573 VGND.n572 175.546
R1803 VGND.n577 VGND.n576 175.546
R1804 VGND.n1656 VGND.n549 175.546
R1805 VGND.n1652 VGND.n548 175.546
R1806 VGND.n440 VGND.n439 175.546
R1807 VGND.n325 VGND.n324 175.546
R1808 VGND.n329 VGND.n328 175.546
R1809 VGND.n333 VGND.n332 175.546
R1810 VGND.n337 VGND.n336 175.546
R1811 VGND.n338 VGND.n314 175.546
R1812 VGND.n515 VGND.n468 175.546
R1813 VGND.n519 VGND.n517 175.546
R1814 VGND.n527 VGND.n466 175.546
R1815 VGND.n531 VGND.n529 175.546
R1816 VGND.n537 VGND.n464 175.546
R1817 VGND.n942 VGND.n306 175.546
R1818 VGND.n1705 VGND.n307 175.546
R1819 VGND.n1688 VGND.n1687 175.546
R1820 VGND.n454 VGND.n453 175.546
R1821 VGND.n1674 VGND.n1673 175.546
R1822 VGND.n842 VGND.n837 175.546
R1823 VGND.n846 VGND.n844 175.546
R1824 VGND.n852 VGND.n831 175.546
R1825 VGND.n856 VGND.n854 175.546
R1826 VGND.n865 VGND.n821 175.546
R1827 VGND.n1966 VGND.n1965 175.546
R1828 VGND.n1965 VGND.n79 175.546
R1829 VGND.n1961 VGND.n79 175.546
R1830 VGND.n1961 VGND.n81 175.546
R1831 VGND.n1957 VGND.n81 175.546
R1832 VGND.n1957 VGND.n83 175.546
R1833 VGND.n1953 VGND.n83 175.546
R1834 VGND.n1953 VGND.n85 175.546
R1835 VGND.n1949 VGND.n85 175.546
R1836 VGND.n1949 VGND.n88 175.546
R1837 VGND.n1945 VGND.n88 175.546
R1838 VGND.n1927 VGND.n113 175.546
R1839 VGND.n132 VGND.n131 175.546
R1840 VGND.n142 VGND.n141 175.546
R1841 VGND.n1922 VGND.n121 175.546
R1842 VGND.n152 VGND.n120 175.546
R1843 VGND.n1696 VGND.n313 175.546
R1844 VGND.n1694 VGND.n1693 175.546
R1845 VGND.n1691 VGND.n443 175.546
R1846 VGND.n1679 VGND.n457 175.546
R1847 VGND.n1677 VGND.n458 175.546
R1848 VGND.n566 VGND.n565 175.546
R1849 VGND.n571 VGND.n570 175.546
R1850 VGND.n579 VGND.n564 175.546
R1851 VGND.n580 VGND.n551 175.546
R1852 VGND.n553 VGND.n552 175.546
R1853 VGND.n1304 VGND.n666 175.546
R1854 VGND.n691 VGND.n690 175.546
R1855 VGND.n1280 VGND.n1279 175.546
R1856 VGND.n1288 VGND.n1287 175.546
R1857 VGND.n1300 VGND.n1299 175.546
R1858 VGND.n159 VGND.n158 175.546
R1859 VGND.n160 VGND.n159 175.546
R1860 VGND.n164 VGND.n160 175.546
R1861 VGND.n165 VGND.n164 175.546
R1862 VGND.n1900 VGND.n165 175.546
R1863 VGND.n1900 VGND.n1899 175.546
R1864 VGND.n1899 VGND.n168 175.546
R1865 VGND.n172 VGND.n168 175.546
R1866 VGND.n173 VGND.n172 175.546
R1867 VGND.n177 VGND.n173 175.546
R1868 VGND.n178 VGND.n177 175.546
R1869 VGND.n1314 VGND.n592 175.546
R1870 VGND.n693 VGND.n591 175.546
R1871 VGND.n686 VGND.n685 175.546
R1872 VGND.n682 VGND.n681 175.546
R1873 VGND.n1318 VGND.n586 175.546
R1874 VGND.n1462 VGND.n1328 175.546
R1875 VGND.n1460 VGND.n1459 175.546
R1876 VGND.n1457 VGND.n1331 175.546
R1877 VGND.n1453 VGND.n1452 175.546
R1878 VGND.n1450 VGND.n1341 175.546
R1879 VGND.n1446 VGND.n1445 175.546
R1880 VGND.n1432 VGND.n1350 175.546
R1881 VGND.n1432 VGND.n1352 175.546
R1882 VGND.n1428 VGND.n1352 175.546
R1883 VGND.n1428 VGND.n263 175.546
R1884 VGND.n1758 VGND.n263 175.546
R1885 VGND.n1758 VGND.n249 175.546
R1886 VGND.n1776 VGND.n249 175.546
R1887 VGND.n1776 VGND.n250 175.546
R1888 VGND.n1772 VGND.n250 175.546
R1889 VGND.n1772 VGND.n253 175.546
R1890 VGND.n1753 VGND.n253 175.546
R1891 VGND.n1465 VGND.n1464 175.546
R1892 VGND.n1333 VGND.n1332 175.546
R1893 VGND.n1336 VGND.n1335 175.546
R1894 VGND.n1342 VGND.n1338 175.546
R1895 VGND.n1345 VGND.n1344 175.546
R1896 VGND.n1436 VGND.n1347 175.546
R1897 VGND.n1930 VGND.n111 175.546
R1898 VGND.n135 VGND.n128 175.546
R1899 VGND.n138 VGND.n137 175.546
R1900 VGND.n147 VGND.n146 175.546
R1901 VGND.n1919 VGND.n1918 175.546
R1902 VGND.n1152 VGND.n728 175.546
R1903 VGND.n1064 VGND.n1063 175.546
R1904 VGND.n1072 VGND.n1071 175.546
R1905 VGND.n1078 VGND.n1054 175.546
R1906 VGND.n1148 VGND.n1055 175.546
R1907 VGND.n1028 VGND.n1026 175.546
R1908 VGND.n1033 VGND.n733 175.546
R1909 VGND.n1037 VGND.n1035 175.546
R1910 VGND.n1041 VGND.n731 175.546
R1911 VGND.n1045 VGND.n1043 175.546
R1912 VGND.n1019 VGND.n737 175.546
R1913 VGND.n1016 VGND.n743 175.546
R1914 VGND.n793 VGND.n792 175.546
R1915 VGND.n801 VGND.n800 175.546
R1916 VGND.n809 VGND.n808 175.546
R1917 VGND.n811 VGND.n738 175.546
R1918 VGND.n840 VGND.n839 175.546
R1919 VGND.n834 VGND.n833 175.546
R1920 VGND.n850 VGND.n849 175.546
R1921 VGND.n858 VGND.n829 175.546
R1922 VGND.n863 VGND.n823 175.546
R1923 VGND.n1013 VGND.n746 175.546
R1924 VGND.n1011 VGND.n755 175.546
R1925 VGND.n797 VGND.n796 175.546
R1926 VGND.n805 VGND.n804 175.546
R1927 VGND.n816 VGND.n815 175.546
R1928 VGND.n45 VGND.n42 175.546
R1929 VGND.n2001 VGND.n36 175.546
R1930 VGND.n748 VGND.n37 175.546
R1931 VGND.n1994 VGND.n60 175.546
R1932 VGND.n1990 VGND.n60 175.546
R1933 VGND.n1990 VGND.n62 175.546
R1934 VGND.n1986 VGND.n62 175.546
R1935 VGND.n1986 VGND.n65 175.546
R1936 VGND.n1982 VGND.n65 175.546
R1937 VGND.n1982 VGND.n66 175.546
R1938 VGND.n1978 VGND.n66 175.546
R1939 VGND.n1978 VGND.n68 175.546
R1940 VGND.n1974 VGND.n68 175.546
R1941 VGND.n1974 VGND.n71 175.546
R1942 VGND.n1878 VGND.n1867 175.546
R1943 VGND.n1874 VGND.n1873 175.546
R1944 VGND.n1870 VGND.n1869 175.546
R1945 VGND.n191 VGND.n188 175.546
R1946 VGND.n1170 VGND.n55 175.546
R1947 VGND.n1174 VGND.n1173 175.546
R1948 VGND.n1270 VGND.n1269 175.546
R1949 VGND.n1266 VGND.n1265 175.546
R1950 VGND.n1262 VGND.n1261 175.546
R1951 VGND.n1258 VGND.n54 175.546
R1952 VGND.n1162 VGND.n698 175.546
R1953 VGND.n1066 VGND.n703 175.546
R1954 VGND.n1059 VGND.n1058 175.546
R1955 VGND.n1081 VGND.n1080 175.546
R1956 VGND.n1145 VGND.n1144 175.546
R1957 VGND.n1911 VGND.n156 175.546
R1958 VGND.n1907 VGND.n156 175.546
R1959 VGND.n1907 VGND.n162 175.546
R1960 VGND.n1903 VGND.n162 175.546
R1961 VGND.n1903 VGND.n167 175.546
R1962 VGND.n1897 VGND.n167 175.546
R1963 VGND.n1897 VGND.n1896 175.546
R1964 VGND.n1896 VGND.n171 175.546
R1965 VGND.n1892 VGND.n171 175.546
R1966 VGND.n1892 VGND.n175 175.546
R1967 VGND.n1888 VGND.n175 175.546
R1968 VGND.n1789 VGND.n227 174.452
R1969 VGND.n490 VGND.t1 167.392
R1970 VGND.n1880 VGND.n183 165.702
R1971 VGND.n1884 VGND.n183 165.702
R1972 VGND.n1861 VGND.n1860 165.702
R1973 VGND.n1860 VGND.n202 165.702
R1974 VGND.n1856 VGND.n202 165.702
R1975 VGND.n1856 VGND.n205 165.702
R1976 VGND.n230 VGND.n205 165.702
R1977 VGND.n240 VGND.n230 165.702
R1978 VGND.n984 VGND.n763 163.333
R1979 VGND.n1404 VGND.n1359 163.333
R1980 VGND.n1619 VGND.n1618 163.333
R1981 VGND.n382 VGND.n353 163.333
R1982 VGND.n648 VGND.n647 163.333
R1983 VGND.n1104 VGND.n1103 163.333
R1984 VGND.n1829 VGND.n213 163.333
R1985 VGND.n924 VGND.n922 163.333
R1986 VGND.n1862 VGND.t25 156.472
R1987 VGND.n2014 VGND.n30 155.239
R1988 VGND.n69 VGND.t6 153.043
R1989 VGND.n1939 VGND.n98 152.643
R1990 VGND.n1664 VGND.n538 152.643
R1991 VGND.n58 VGND.n39 152.643
R1992 VGND.n58 VGND.n40 152.643
R1993 VGND.n57 VGND.n40 152.643
R1994 VGND.n57 VGND.n41 152.643
R1995 VGND.n1442 VGND.n1439 151.66
R1996 VGND.n1215 VGND.n1214 150
R1997 VGND.n1211 VGND.n1210 150
R1998 VGND.n1207 VGND.n1206 150
R1999 VGND.n1203 VGND.n1202 150
R2000 VGND.n1250 VGND.n1199 150
R2001 VGND.n1250 VGND.n1200 150
R2002 VGND.n1246 VGND.n1245 150
R2003 VGND.n1242 VGND.n1241 150
R2004 VGND.n1238 VGND.n1237 150
R2005 VGND.n1234 VGND.n1233 150
R2006 VGND.n1230 VGND.n1229 150
R2007 VGND.n1226 VGND.n1225 150
R2008 VGND.n1222 VGND.n1221 150
R2009 VGND.n980 VGND.n978 150
R2010 VGND.n976 VGND.n765 150
R2011 VGND.n972 VGND.n970 150
R2012 VGND.n967 VGND.n966 150
R2013 VGND.n964 VGND.n768 150
R2014 VGND.n960 VGND.n959 150
R2015 VGND.n957 VGND.n771 150
R2016 VGND.n953 VGND.n952 150
R2017 VGND.n1006 VGND.n1005 150
R2018 VGND.n1008 VGND.n758 150
R2019 VGND.n787 VGND.n785 150
R2020 VGND.n783 VGND.n782 150
R2021 VGND.n988 VGND.n986 150
R2022 VGND.n992 VGND.n761 150
R2023 VGND.n996 VGND.n994 150
R2024 VGND.n1003 VGND.n759 150
R2025 VGND.n1400 VGND.n1398 150
R2026 VGND.n1396 VGND.n1361 150
R2027 VGND.n1392 VGND.n1390 150
R2028 VGND.n1387 VGND.n1386 150
R2029 VGND.n1384 VGND.n1364 150
R2030 VGND.n1380 VGND.n1379 150
R2031 VGND.n1377 VGND.n1367 150
R2032 VGND.n1373 VGND.n1372 150
R2033 VGND.n1424 VGND.n1422 150
R2034 VGND.n1761 VGND.n260 150
R2035 VGND.n1764 VGND.n1763 150
R2036 VGND.n1767 VGND.n1766 150
R2037 VGND.n1408 VGND.n1406 150
R2038 VGND.n1412 VGND.n1357 150
R2039 VGND.n1416 VGND.n1414 150
R2040 VGND.n1420 VGND.n1355 150
R2041 VGND.n1615 VGND.n1614 150
R2042 VGND.n1611 VGND.n1610 150
R2043 VGND.n1607 VGND.n1606 150
R2044 VGND.n1603 VGND.n1602 150
R2045 VGND.n1599 VGND.n1598 150
R2046 VGND.n1595 VGND.n1594 150
R2047 VGND.n1591 VGND.n1590 150
R2048 VGND.n1587 VGND.n1586 150
R2049 VGND.n1640 VGND.n1474 150
R2050 VGND.n1540 VGND.n1475 150
R2051 VGND.n1553 VGND.n1552 150
R2052 VGND.n1535 VGND.n1534 150
R2053 VGND.n1623 VGND.n1622 150
R2054 VGND.n1627 VGND.n1626 150
R2055 VGND.n1631 VGND.n1630 150
R2056 VGND.n1637 VGND.n1492 150
R2057 VGND.n380 VGND.n379 150
R2058 VGND.n376 VGND.n375 150
R2059 VGND.n372 VGND.n371 150
R2060 VGND.n368 VGND.n367 150
R2061 VGND.n364 VGND.n363 150
R2062 VGND.n360 VGND.n359 150
R2063 VGND.n356 VGND.n342 150
R2064 VGND.n403 VGND.n402 150
R2065 VGND.n435 VGND.n434 150
R2066 VGND.n428 VGND.n427 150
R2067 VGND.n421 VGND.n420 150
R2068 VGND.n414 VGND.n413 150
R2069 VGND.n399 VGND.n354 150
R2070 VGND.n395 VGND.n394 150
R2071 VGND.n391 VGND.n390 150
R2072 VGND.n387 VGND.n386 150
R2073 VGND.n644 VGND.n643 150
R2074 VGND.n640 VGND.n639 150
R2075 VGND.n636 VGND.n635 150
R2076 VGND.n632 VGND.n631 150
R2077 VGND.n628 VGND.n627 150
R2078 VGND.n624 VGND.n623 150
R2079 VGND.n620 VGND.n619 150
R2080 VGND.n616 VGND.n615 150
R2081 VGND.n1311 VGND.n595 150
R2082 VGND.n1276 VGND.n596 150
R2083 VGND.n1284 VGND.n1283 150
R2084 VGND.n1292 VGND.n1291 150
R2085 VGND.n652 VGND.n651 150
R2086 VGND.n656 VGND.n655 150
R2087 VGND.n660 VGND.n659 150
R2088 VGND.n1308 VGND.n613 150
R2089 VGND.n1108 VGND.n1107 150
R2090 VGND.n1112 VGND.n1111 150
R2091 VGND.n1116 VGND.n1115 150
R2092 VGND.n1120 VGND.n1119 150
R2093 VGND.n1124 VGND.n1123 150
R2094 VGND.n1128 VGND.n1127 150
R2095 VGND.n1132 VGND.n1131 150
R2096 VGND.n1136 VGND.n1135 150
R2097 VGND.n1159 VGND.n706 150
R2098 VGND.n1068 VGND.n707 150
R2099 VGND.n1076 VGND.n1075 150
R2100 VGND.n1086 VGND.n1085 150
R2101 VGND.n1100 VGND.n1099 150
R2102 VGND.n1096 VGND.n1095 150
R2103 VGND.n1092 VGND.n1091 150
R2104 VGND.n1156 VGND.n724 150
R2105 VGND.n1825 VGND.n1823 150
R2106 VGND.n1821 VGND.n215 150
R2107 VGND.n1817 VGND.n215 150
R2108 VGND.n1815 VGND.n216 150
R2109 VGND.n1809 VGND.n1808 150
R2110 VGND.n1806 VGND.n219 150
R2111 VGND.n1802 VGND.n1801 150
R2112 VGND.n1799 VGND.n222 150
R2113 VGND.n1851 VGND.n1850 150
R2114 VGND.n1853 VGND.n208 150
R2115 VGND.n237 VGND.n236 150
R2116 VGND.n1833 VGND.n1831 150
R2117 VGND.n1837 VGND.n211 150
R2118 VGND.n1841 VGND.n1839 150
R2119 VGND.n1846 VGND.n209 150
R2120 VGND.n920 VGND.n878 150
R2121 VGND.n916 VGND.n914 150
R2122 VGND.n912 VGND.n880 150
R2123 VGND.n908 VGND.n906 150
R2124 VGND.n904 VGND.n882 150
R2125 VGND.n900 VGND.n899 150
R2126 VGND.n897 VGND.n885 150
R2127 VGND.n893 VGND.n892 150
R2128 VGND.n1700 VGND.n311 150
R2129 VGND.n1702 VGND.n310 150
R2130 VGND.n1684 VGND.n450 150
R2131 VGND.n1682 VGND.n451 150
R2132 VGND.n928 VGND.n876 150
R2133 VGND.n932 VGND.n930 150
R2134 VGND.n936 VGND.n874 150
R2135 VGND.n940 VGND.n938 150
R2136 VGND.n186 VGND.n185 149.952
R2137 VGND.n1944 VGND.t3 148.262
R2138 VGND.n240 VGND.n200 147.291
R2139 VGND.t26 VGND.n2016 145.605
R2140 VGND.n1442 VGND.n244 140.714
R2141 VGND.n30 VGND.n13 139.446
R2142 VGND.n1864 VGND.n1863 135.609
R2143 VGND.t4 VGND.n1958 133.913
R2144 VGND.n0 VGND.t41 1.76041
R2145 VGND.n243 VGND.n227 128.796
R2146 VGND.n1729 VGND.n288 126.782
R2147 VGND.n1575 VGND.n1565 126.782
R2148 VGND.n1505 VGND.n104 126.782
R2149 VGND.n468 VGND.n90 126.782
R2150 VGND.n539 VGND.n105 126.782
R2151 VGND.n1328 VGND.n1327 126.782
R2152 VGND.n1932 VGND.n109 126.782
R2153 VGND.n824 VGND.n73 126.782
R2154 VGND.n1913 VGND.n1911 126.782
R2155 VGND.n510 VGND.n509 124.832
R2156 VGND.n1660 VGND.n102 124.832
R2157 VGND.n835 VGND.n75 124.832
R2158 VGND.n1925 VGND.n106 124.832
R2159 VGND.n671 VGND.n158 124.832
R2160 VGND.n1466 VGND.n1465 124.832
R2161 VGND.n1024 VGND.n735 124.832
R2162 VGND.n1996 VGND.n56 124.832
R2163 VGND.n697 VGND.n55 124.832
R2164 VGND.n1018 VGND.n0 211.469
R2165 VGND.t7 VGND.n38 121.314
R2166 VGND.t27 VGND.n2015 118.936
R2167 VGND.n11 VGND.n9 117.001
R2168 VGND.n12 VGND.n11 117.001
R2169 VGND.n477 VGND.t2 114.784
R2170 VGND.t21 VGND.t19 114.317
R2171 VGND.t22 VGND.t21 114.317
R2172 VGND.t36 VGND.n1983 112.391
R2173 VGND.n86 VGND.t36 112.391
R2174 VGND.t36 VGND.n497 112.391
R2175 VGND.t23 VGND.n179 110.575
R2176 VGND.n2017 VGND.t26 108.903
R2177 VGND.n1184 VGND.n1178 106.733
R2178 VGND.n1186 VGND.n1179 106.733
R2179 VGND.n1181 VGND.n1180 106.733
R2180 VGND.n1254 VGND.n1253 106.733
R2181 VGND.n1254 VGND.n1181 106.733
R2182 VGND.n1186 VGND.n1180 106.733
R2183 VGND.n1184 VGND.n1179 106.733
R2184 VGND.n1792 VGND.n225 106.733
R2185 VGND.n1793 VGND.n1792 106.733
R2186 VGND.n1984 VGND.t36 102.826
R2187 VGND.n1958 VGND.t36 102.826
R2188 VGND.n498 VGND.t36 102.826
R2189 VGND.n505 VGND.t2 100.436
R2190 VGND.n241 VGND.t34 98.0565
R2191 VGND.t34 VGND.n251 98.0565
R2192 VGND.n190 VGND.t41 98.0565
R2193 VGND.n1757 VGND.t34 89.7113
R2194 VGND.n1868 VGND.t41 89.7113
R2195 VGND.n2018 VGND.n2017 83.7106
R2196 VGND.n2019 VGND.n2018 83.5719
R2197 VGND.n1781 VGND.n245 83.5719
R2198 VGND.n1440 VGND.n245 83.5719
R2199 VGND.n2019 VGND.n10 81.9585
R2200 VGND.n1164 VGND.t41 212.636
R2201 VGND.n1959 VGND.t4 81.3049
R2202 VGND.t3 VGND.n1943 81.3049
R2203 VGND.t18 VGND.t34 79.2798
R2204 VGND.n1316 VGND.t34 209.756
R2205 VGND.n1879 VGND.n1866 78.8207
R2206 VGND.n510 VGND.n97 76.3222
R2207 VGND.n512 VGND.n96 76.3222
R2208 VGND.n522 VGND.n95 76.3222
R2209 VGND.n524 VGND.n94 76.3222
R2210 VGND.n1728 VGND.n1727 76.3222
R2211 VGND.n1725 VGND.n1724 76.3222
R2212 VGND.n1721 VGND.n1720 76.3222
R2213 VGND.n1718 VGND.n1717 76.3222
R2214 VGND.n1713 VGND.n294 76.3222
R2215 VGND.n1711 VGND.n1710 76.3222
R2216 VGND.n430 VGND.n297 76.3222
R2217 VGND.n423 VGND.n298 76.3222
R2218 VGND.n416 VGND.n299 76.3222
R2219 VGND.n409 VGND.n300 76.3222
R2220 VGND.n301 VGND.n295 76.3222
R2221 VGND.n1571 VGND.n266 76.3222
R2222 VGND.n1567 VGND.n267 76.3222
R2223 VGND.n1739 VGND.n268 76.3222
R2224 VGND.n1743 VGND.n269 76.3222
R2225 VGND.n1747 VGND.n270 76.3222
R2226 VGND.n274 VGND.n271 76.3222
R2227 VGND.n1660 VGND.n1659 76.3222
R2228 VGND.n567 VGND.n545 76.3222
R2229 VGND.n573 VGND.n546 76.3222
R2230 VGND.n577 VGND.n547 76.3222
R2231 VGND.n1657 VGND.n1656 76.3222
R2232 VGND.n1648 VGND.n543 76.3222
R2233 VGND.n324 VGND.n315 76.3222
R2234 VGND.n328 VGND.n316 76.3222
R2235 VGND.n332 VGND.n317 76.3222
R2236 VGND.n336 VGND.n318 76.3222
R2237 VGND.n338 VGND.n319 76.3222
R2238 VGND.n517 VGND.n516 76.3222
R2239 VGND.n518 VGND.n466 76.3222
R2240 VGND.n529 VGND.n528 76.3222
R2241 VGND.n530 VGND.n464 76.3222
R2242 VGND.n1665 VGND.n1664 76.3222
R2243 VGND.n868 VGND.n302 76.3222
R2244 VGND.n1706 VGND.n1705 76.3222
R2245 VGND.n1688 VGND.n305 76.3222
R2246 VGND.n453 VGND.n304 76.3222
R2247 VGND.n1674 VGND.n303 76.3222
R2248 VGND.n1666 VGND.n296 76.3222
R2249 VGND.n836 VGND.n835 76.3222
R2250 VGND.n843 VGND.n842 76.3222
R2251 VGND.n846 VGND.n845 76.3222
R2252 VGND.n853 VGND.n852 76.3222
R2253 VGND.n856 VGND.n855 76.3222
R2254 VGND.n866 VGND.n865 76.3222
R2255 VGND.n337 VGND.n319 76.3222
R2256 VGND.n333 VGND.n318 76.3222
R2257 VGND.n329 VGND.n317 76.3222
R2258 VGND.n325 VGND.n316 76.3222
R2259 VGND.n439 VGND.n315 76.3222
R2260 VGND.n410 VGND.n301 76.3222
R2261 VGND.n417 VGND.n300 76.3222
R2262 VGND.n424 VGND.n299 76.3222
R2263 VGND.n431 VGND.n298 76.3222
R2264 VGND.n437 VGND.n297 76.3222
R2265 VGND.n1926 VGND.n1925 76.3222
R2266 VGND.n117 VGND.n113 76.3222
R2267 VGND.n131 VGND.n118 76.3222
R2268 VGND.n142 VGND.n119 76.3222
R2269 VGND.n1923 VGND.n1922 76.3222
R2270 VGND.n667 VGND.n115 76.3222
R2271 VGND.n871 VGND.n870 76.3222
R2272 VGND.n1695 VGND.n1694 76.3222
R2273 VGND.n1692 VGND.n1691 76.3222
R2274 VGND.n457 VGND.n456 76.3222
R2275 VGND.n1678 VGND.n1677 76.3222
R2276 VGND.n1669 VGND.n1668 76.3222
R2277 VGND.n565 VGND.n561 76.3222
R2278 VGND.n570 VGND.n562 76.3222
R2279 VGND.n564 VGND.n563 76.3222
R2280 VGND.n581 VGND.n580 76.3222
R2281 VGND.n582 VGND.n552 76.3222
R2282 VGND.n1325 VGND.n1324 76.3222
R2283 VGND.n1303 VGND.n675 76.3222
R2284 VGND.n676 VGND.n666 76.3222
R2285 VGND.n691 VGND.n677 76.3222
R2286 VGND.n1280 VGND.n678 76.3222
R2287 VGND.n1288 VGND.n679 76.3222
R2288 VGND.n1301 VGND.n583 76.3222
R2289 VGND.n1301 VGND.n1300 76.3222
R2290 VGND.n1299 VGND.n679 76.3222
R2291 VGND.n1287 VGND.n678 76.3222
R2292 VGND.n1279 VGND.n677 76.3222
R2293 VGND.n690 VGND.n676 76.3222
R2294 VGND.n1304 VGND.n1303 76.3222
R2295 VGND.n592 VGND.n587 76.3222
R2296 VGND.n1315 VGND.n1314 76.3222
R2297 VGND.n693 VGND.n590 76.3222
R2298 VGND.n686 VGND.n589 76.3222
R2299 VGND.n681 VGND.n588 76.3222
R2300 VGND.n1318 VGND.n1317 76.3222
R2301 VGND.n1315 VGND.n591 76.3222
R2302 VGND.n685 VGND.n590 76.3222
R2303 VGND.n682 VGND.n589 76.3222
R2304 VGND.n588 VGND.n586 76.3222
R2305 VGND.n1461 VGND.n1460 76.3222
R2306 VGND.n1458 VGND.n1457 76.3222
R2307 VGND.n1453 VGND.n1340 76.3222
R2308 VGND.n1451 VGND.n1450 76.3222
R2309 VGND.n1446 VGND.n1349 76.3222
R2310 VGND.n1464 VGND.n558 76.3222
R2311 VGND.n1334 VGND.n1333 76.3222
R2312 VGND.n1337 VGND.n1336 76.3222
R2313 VGND.n1343 VGND.n1342 76.3222
R2314 VGND.n1346 VGND.n1345 76.3222
R2315 VGND.n1332 VGND.n558 76.3222
R2316 VGND.n1335 VGND.n1334 76.3222
R2317 VGND.n1338 VGND.n1337 76.3222
R2318 VGND.n1344 VGND.n1343 76.3222
R2319 VGND.n1347 VGND.n1346 76.3222
R2320 VGND.n1349 VGND.n1341 76.3222
R2321 VGND.n1452 VGND.n1451 76.3222
R2322 VGND.n1340 VGND.n1331 76.3222
R2323 VGND.n1459 VGND.n1458 76.3222
R2324 VGND.n1462 VGND.n1461 76.3222
R2325 VGND.n1317 VGND.n560 76.3222
R2326 VGND.n1325 VGND.n553 76.3222
R2327 VGND.n582 VGND.n551 76.3222
R2328 VGND.n581 VGND.n579 76.3222
R2329 VGND.n571 VGND.n563 76.3222
R2330 VGND.n566 VGND.n562 76.3222
R2331 VGND.n561 VGND.n539 76.3222
R2332 VGND.n1659 VGND.n541 76.3222
R2333 VGND.n572 VGND.n545 76.3222
R2334 VGND.n576 VGND.n546 76.3222
R2335 VGND.n549 VGND.n547 76.3222
R2336 VGND.n1657 VGND.n548 76.3222
R2337 VGND.n1652 VGND.n543 76.3222
R2338 VGND.n1940 VGND.n1939 76.3222
R2339 VGND.n538 VGND.n537 76.3222
R2340 VGND.n531 VGND.n530 76.3222
R2341 VGND.n528 VGND.n527 76.3222
R2342 VGND.n519 VGND.n518 76.3222
R2343 VGND.n516 VGND.n515 76.3222
R2344 VGND.n513 VGND.n97 76.3222
R2345 VGND.n521 VGND.n96 76.3222
R2346 VGND.n525 VGND.n95 76.3222
R2347 VGND.n532 VGND.n94 76.3222
R2348 VGND.n535 VGND.n98 76.3222
R2349 VGND.n294 VGND.n292 76.3222
R2350 VGND.n1719 VGND.n1718 76.3222
R2351 VGND.n1722 VGND.n1721 76.3222
R2352 VGND.n1726 VGND.n1725 76.3222
R2353 VGND.n1729 VGND.n1728 76.3222
R2354 VGND.n1712 VGND.n1711 76.3222
R2355 VGND.n1748 VGND.n271 76.3222
R2356 VGND.n1744 VGND.n270 76.3222
R2357 VGND.n1740 VGND.n269 76.3222
R2358 VGND.n1566 VGND.n268 76.3222
R2359 VGND.n1570 VGND.n267 76.3222
R2360 VGND.n1565 VGND.n266 76.3222
R2361 VGND.n1931 VGND.n1930 76.3222
R2362 VGND.n128 VGND.n127 76.3222
R2363 VGND.n138 VGND.n136 76.3222
R2364 VGND.n146 VGND.n124 76.3222
R2365 VGND.n1919 VGND.n148 76.3222
R2366 VGND.n1917 VGND.n1916 76.3222
R2367 VGND.n1151 VGND.n1049 76.3222
R2368 VGND.n1051 VGND.n728 76.3222
R2369 VGND.n1064 VGND.n1052 76.3222
R2370 VGND.n1072 VGND.n1053 76.3222
R2371 VGND.n1149 VGND.n1054 76.3222
R2372 VGND.n1050 VGND.n150 76.3222
R2373 VGND.n1055 VGND.n1050 76.3222
R2374 VGND.n1149 VGND.n1148 76.3222
R2375 VGND.n1078 VGND.n1053 76.3222
R2376 VGND.n1071 VGND.n1052 76.3222
R2377 VGND.n1063 VGND.n1051 76.3222
R2378 VGND.n1152 VGND.n1151 76.3222
R2379 VGND.n1025 VGND.n1024 76.3222
R2380 VGND.n1028 VGND.n1027 76.3222
R2381 VGND.n1034 VGND.n1033 76.3222
R2382 VGND.n1037 VGND.n1036 76.3222
R2383 VGND.n1042 VGND.n1041 76.3222
R2384 VGND.n1045 VGND.n1044 76.3222
R2385 VGND.n1017 VGND.n1016 76.3222
R2386 VGND.n792 VGND.n742 76.3222
R2387 VGND.n800 VGND.n741 76.3222
R2388 VGND.n808 VGND.n740 76.3222
R2389 VGND.n811 VGND.n739 76.3222
R2390 VGND.n809 VGND.n739 76.3222
R2391 VGND.n801 VGND.n740 76.3222
R2392 VGND.n793 VGND.n741 76.3222
R2393 VGND.n743 VGND.n742 76.3222
R2394 VGND.n1017 VGND.n737 76.3222
R2395 VGND.n839 VGND.n825 76.3222
R2396 VGND.n833 VGND.n826 76.3222
R2397 VGND.n849 VGND.n827 76.3222
R2398 VGND.n829 VGND.n828 76.3222
R2399 VGND.n859 VGND.n823 76.3222
R2400 VGND.n862 VGND.n861 76.3222
R2401 VGND.n753 VGND.n746 76.3222
R2402 VGND.n1012 VGND.n1011 76.3222
R2403 VGND.n796 VGND.n789 76.3222
R2404 VGND.n804 VGND.n779 76.3222
R2405 VGND.n815 VGND.n776 76.3222
R2406 VGND.n818 VGND.n817 76.3222
R2407 VGND.n817 VGND.n816 76.3222
R2408 VGND.n805 VGND.n776 76.3222
R2409 VGND.n797 VGND.n779 76.3222
R2410 VGND.n789 VGND.n755 76.3222
R2411 VGND.n1013 VGND.n1012 76.3222
R2412 VGND.n1996 VGND.n39 76.3222
R2413 VGND.n46 VGND.n45 76.3222
R2414 VGND.n2001 VGND.n2000 76.3222
R2415 VGND.n748 VGND.n47 76.3222
R2416 VGND.n859 VGND.n858 76.3222
R2417 VGND.n850 VGND.n828 76.3222
R2418 VGND.n834 VGND.n827 76.3222
R2419 VGND.n840 VGND.n826 76.3222
R2420 VGND.n825 VGND.n824 76.3222
R2421 VGND.n837 VGND.n836 76.3222
R2422 VGND.n844 VGND.n843 76.3222
R2423 VGND.n845 VGND.n831 76.3222
R2424 VGND.n854 VGND.n853 76.3222
R2425 VGND.n855 VGND.n821 76.3222
R2426 VGND.n42 VGND.n41 76.3222
R2427 VGND.n46 VGND.n36 76.3222
R2428 VGND.n2000 VGND.n37 76.3222
R2429 VGND.n747 VGND.n47 76.3222
R2430 VGND.n753 VGND.n752 76.3222
R2431 VGND.n1026 VGND.n1025 76.3222
R2432 VGND.n1027 VGND.n733 76.3222
R2433 VGND.n1035 VGND.n1034 76.3222
R2434 VGND.n1036 VGND.n731 76.3222
R2435 VGND.n1043 VGND.n1042 76.3222
R2436 VGND.n1044 VGND.n729 76.3222
R2437 VGND.n1874 VGND.n194 76.3222
R2438 VGND.n1870 VGND.n193 76.3222
R2439 VGND.n192 VGND.n191 76.3222
R2440 VGND.n187 VGND.n186 76.3222
R2441 VGND.n1867 VGND.n194 76.3222
R2442 VGND.n1873 VGND.n193 76.3222
R2443 VGND.n1869 VGND.n192 76.3222
R2444 VGND.n188 VGND.n187 76.3222
R2445 VGND.n1170 VGND.n49 76.3222
R2446 VGND.n1174 VGND.n50 76.3222
R2447 VGND.n1269 VGND.n51 76.3222
R2448 VGND.n1265 VGND.n52 76.3222
R2449 VGND.n1261 VGND.n53 76.3222
R2450 VGND.n1173 VGND.n49 76.3222
R2451 VGND.n1270 VGND.n50 76.3222
R2452 VGND.n1266 VGND.n51 76.3222
R2453 VGND.n1262 VGND.n52 76.3222
R2454 VGND.n1258 VGND.n53 76.3222
R2455 VGND.n1166 VGND.n1165 76.3222
R2456 VGND.n1163 VGND.n1162 76.3222
R2457 VGND.n1066 VGND.n702 76.3222
R2458 VGND.n1059 VGND.n701 76.3222
R2459 VGND.n1080 VGND.n700 76.3222
R2460 VGND.n1144 VGND.n699 76.3222
R2461 VGND.n1165 VGND.n698 76.3222
R2462 VGND.n1163 VGND.n703 76.3222
R2463 VGND.n1058 VGND.n702 76.3222
R2464 VGND.n1081 VGND.n701 76.3222
R2465 VGND.n1145 VGND.n700 76.3222
R2466 VGND.n670 VGND.n587 76.3222
R2467 VGND.n699 VGND.n155 76.3222
R2468 VGND.n1918 VGND.n1917 76.3222
R2469 VGND.n148 VGND.n147 76.3222
R2470 VGND.n137 VGND.n124 76.3222
R2471 VGND.n136 VGND.n135 76.3222
R2472 VGND.n127 VGND.n111 76.3222
R2473 VGND.n1932 VGND.n1931 76.3222
R2474 VGND.n1927 VGND.n1926 76.3222
R2475 VGND.n132 VGND.n117 76.3222
R2476 VGND.n141 VGND.n118 76.3222
R2477 VGND.n121 VGND.n119 76.3222
R2478 VGND.n1923 VGND.n120 76.3222
R2479 VGND.n152 VGND.n115 76.3222
R2480 VGND.n863 VGND.n862 76.3222
R2481 VGND.n867 VGND.n866 76.3222
R2482 VGND.n1668 VGND.n458 76.3222
R2483 VGND.n1679 VGND.n1678 76.3222
R2484 VGND.n456 VGND.n443 76.3222
R2485 VGND.n1693 VGND.n1692 76.3222
R2486 VGND.n1696 VGND.n1695 76.3222
R2487 VGND.n870 VGND.n313 76.3222
R2488 VGND.n1673 VGND.n296 76.3222
R2489 VGND.n454 VGND.n303 76.3222
R2490 VGND.n1687 VGND.n304 76.3222
R2491 VGND.n307 VGND.n305 76.3222
R2492 VGND.n1706 VGND.n306 76.3222
R2493 VGND.n942 VGND.n302 76.3222
R2494 VGND.n1005 VGND.n1004 74.5978
R2495 VGND.n1004 VGND.n1003 74.5978
R2496 VGND.n1422 VGND.n1421 74.5978
R2497 VGND.n1421 VGND.n1420 74.5978
R2498 VGND.n1638 VGND.n1474 74.5978
R2499 VGND.n1638 VGND.n1637 74.5978
R2500 VGND.n435 VGND.n322 74.5978
R2501 VGND.n386 VGND.n322 74.5978
R2502 VGND.n1309 VGND.n595 74.5978
R2503 VGND.n1309 VGND.n1308 74.5978
R2504 VGND.n1157 VGND.n706 74.5978
R2505 VGND.n1157 VGND.n1156 74.5978
R2506 VGND.n1850 VGND.n1847 74.5978
R2507 VGND.n1847 VGND.n1846 74.5978
R2508 VGND.n939 VGND.n311 74.5978
R2509 VGND.n940 VGND.n939 74.5978
R2510 VGND.n1792 VGND.n1791 74.565
R2511 VGND.n1866 VGND.n199 69.3303
R2512 VGND.n1237 VGND.n1192 69.3109
R2513 VGND.n1234 VGND.n1192 69.3109
R2514 VGND.n966 VGND.n965 69.3109
R2515 VGND.n965 VGND.n964 69.3109
R2516 VGND.n1386 VGND.n1385 69.3109
R2517 VGND.n1385 VGND.n1384 69.3109
R2518 VGND.n1602 VGND.n1481 69.3109
R2519 VGND.n1599 VGND.n1481 69.3109
R2520 VGND.n367 VGND.n345 69.3109
R2521 VGND.n364 VGND.n345 69.3109
R2522 VGND.n631 VGND.n602 69.3109
R2523 VGND.n628 VGND.n602 69.3109
R2524 VGND.n1120 VGND.n713 69.3109
R2525 VGND.n1123 VGND.n713 69.3109
R2526 VGND.n906 VGND.n905 69.3109
R2527 VGND.n905 VGND.n904 69.3109
R2528 VGND.n1936 VGND.t34 67.8333
R2529 VGND.n1755 VGND.n272 67.1761
R2530 VGND.n1707 VGND.t36 66.1603
R2531 VGND.t44 VGND.n1191 65.8183
R2532 VGND.t44 VGND.n1190 65.8183
R2533 VGND.t44 VGND.n1189 65.8183
R2534 VGND.t44 VGND.n1188 65.8183
R2535 VGND.t44 VGND.n1187 65.8183
R2536 VGND.t44 VGND.n1193 65.8183
R2537 VGND.t44 VGND.n1185 65.8183
R2538 VGND.t44 VGND.n1195 65.8183
R2539 VGND.t44 VGND.n1196 65.8183
R2540 VGND.t44 VGND.n1197 65.8183
R2541 VGND.t44 VGND.n1198 65.8183
R2542 VGND.n985 VGND.t38 65.8183
R2543 VGND.n987 VGND.t38 65.8183
R2544 VGND.n993 VGND.t38 65.8183
R2545 VGND.n995 VGND.t38 65.8183
R2546 VGND.n766 VGND.t38 65.8183
R2547 VGND.n971 VGND.t38 65.8183
R2548 VGND.n977 VGND.t38 65.8183
R2549 VGND.n979 VGND.t38 65.8183
R2550 VGND.n951 VGND.t38 65.8183
R2551 VGND.n773 VGND.t38 65.8183
R2552 VGND.n958 VGND.t38 65.8183
R2553 VGND.n770 VGND.t38 65.8183
R2554 VGND.n781 VGND.t38 65.8183
R2555 VGND.n784 VGND.t38 65.8183
R2556 VGND.n786 VGND.t38 65.8183
R2557 VGND.n1007 VGND.t38 65.8183
R2558 VGND.n1405 VGND.t42 65.8183
R2559 VGND.n1407 VGND.t42 65.8183
R2560 VGND.n1413 VGND.t42 65.8183
R2561 VGND.n1415 VGND.t42 65.8183
R2562 VGND.n1362 VGND.t42 65.8183
R2563 VGND.n1391 VGND.t42 65.8183
R2564 VGND.n1397 VGND.t42 65.8183
R2565 VGND.n1399 VGND.t42 65.8183
R2566 VGND.n1371 VGND.t42 65.8183
R2567 VGND.n1370 VGND.t42 65.8183
R2568 VGND.n1378 VGND.t42 65.8183
R2569 VGND.n1366 VGND.t42 65.8183
R2570 VGND.t39 VGND.n1491 65.8183
R2571 VGND.t39 VGND.n1490 65.8183
R2572 VGND.t39 VGND.n1489 65.8183
R2573 VGND.t39 VGND.n1488 65.8183
R2574 VGND.t39 VGND.n1479 65.8183
R2575 VGND.t39 VGND.n1486 65.8183
R2576 VGND.t39 VGND.n1476 65.8183
R2577 VGND.t39 VGND.n1487 65.8183
R2578 VGND.t39 VGND.n1485 65.8183
R2579 VGND.t39 VGND.n1484 65.8183
R2580 VGND.t39 VGND.n1483 65.8183
R2581 VGND.t39 VGND.n1482 65.8183
R2582 VGND.t39 VGND.n1480 65.8183
R2583 VGND.t39 VGND.n1478 65.8183
R2584 VGND.t39 VGND.n1477 65.8183
R2585 VGND.n1639 VGND.t39 65.8183
R2586 VGND.t35 VGND.n400 65.8183
R2587 VGND.t35 VGND.n352 65.8183
R2588 VGND.t35 VGND.n351 65.8183
R2589 VGND.t35 VGND.n350 65.8183
R2590 VGND.t35 VGND.n344 65.8183
R2591 VGND.t35 VGND.n348 65.8183
R2592 VGND.t35 VGND.n343 65.8183
R2593 VGND.t35 VGND.n349 65.8183
R2594 VGND.t35 VGND.n340 65.8183
R2595 VGND.n401 VGND.t35 65.8183
R2596 VGND.t35 VGND.n347 65.8183
R2597 VGND.t35 VGND.n346 65.8183
R2598 VGND.t35 VGND.n335 65.8183
R2599 VGND.t35 VGND.n331 65.8183
R2600 VGND.t35 VGND.n327 65.8183
R2601 VGND.t35 VGND.n323 65.8183
R2602 VGND.t33 VGND.n612 65.8183
R2603 VGND.t33 VGND.n611 65.8183
R2604 VGND.t33 VGND.n610 65.8183
R2605 VGND.t33 VGND.n609 65.8183
R2606 VGND.t33 VGND.n600 65.8183
R2607 VGND.t33 VGND.n607 65.8183
R2608 VGND.t33 VGND.n597 65.8183
R2609 VGND.t33 VGND.n608 65.8183
R2610 VGND.t33 VGND.n606 65.8183
R2611 VGND.t33 VGND.n605 65.8183
R2612 VGND.t33 VGND.n604 65.8183
R2613 VGND.t33 VGND.n603 65.8183
R2614 VGND.t33 VGND.n601 65.8183
R2615 VGND.t33 VGND.n599 65.8183
R2616 VGND.t33 VGND.n598 65.8183
R2617 VGND.n1310 VGND.t33 65.8183
R2618 VGND.n1768 VGND.t42 65.8183
R2619 VGND.n1765 VGND.t42 65.8183
R2620 VGND.n1762 VGND.t42 65.8183
R2621 VGND.n1423 VGND.t42 65.8183
R2622 VGND.t40 VGND.n723 65.8183
R2623 VGND.t40 VGND.n722 65.8183
R2624 VGND.t40 VGND.n721 65.8183
R2625 VGND.t40 VGND.n720 65.8183
R2626 VGND.t40 VGND.n711 65.8183
R2627 VGND.t40 VGND.n718 65.8183
R2628 VGND.t40 VGND.n708 65.8183
R2629 VGND.t40 VGND.n719 65.8183
R2630 VGND.t40 VGND.n717 65.8183
R2631 VGND.t40 VGND.n716 65.8183
R2632 VGND.t40 VGND.n715 65.8183
R2633 VGND.t40 VGND.n714 65.8183
R2634 VGND.t40 VGND.n712 65.8183
R2635 VGND.t40 VGND.n710 65.8183
R2636 VGND.t40 VGND.n709 65.8183
R2637 VGND.n1158 VGND.t40 65.8183
R2638 VGND.n1256 VGND.n1254 65.8183
R2639 VGND.n1253 VGND.t44 65.8183
R2640 VGND.n1256 VGND.n1180 65.8183
R2641 VGND.t44 VGND.n1181 65.8183
R2642 VGND.n1256 VGND.n1179 65.8183
R2643 VGND.t44 VGND.n1186 65.8183
R2644 VGND.n1256 VGND.n1178 65.8183
R2645 VGND.t44 VGND.n1184 65.8183
R2646 VGND.n1830 VGND.t43 65.8183
R2647 VGND.n1832 VGND.t43 65.8183
R2648 VGND.n1838 VGND.t43 65.8183
R2649 VGND.n1840 VGND.t43 65.8183
R2650 VGND.n1810 VGND.t43 65.8183
R2651 VGND.n1816 VGND.t43 65.8183
R2652 VGND.n1822 VGND.t43 65.8183
R2653 VGND.n1824 VGND.t43 65.8183
R2654 VGND.n224 VGND.t43 65.8183
R2655 VGND.n1800 VGND.t43 65.8183
R2656 VGND.n221 VGND.t43 65.8183
R2657 VGND.n1807 VGND.t43 65.8183
R2658 VGND.n1793 VGND.t43 65.8183
R2659 VGND.n225 VGND.t43 65.8183
R2660 VGND.n235 VGND.t43 65.8183
R2661 VGND.n1852 VGND.t43 65.8183
R2662 VGND.n923 VGND.t37 65.8183
R2663 VGND.n929 VGND.t37 65.8183
R2664 VGND.n931 VGND.t37 65.8183
R2665 VGND.n937 VGND.t37 65.8183
R2666 VGND.n907 VGND.t37 65.8183
R2667 VGND.n913 VGND.t37 65.8183
R2668 VGND.n915 VGND.t37 65.8183
R2669 VGND.n921 VGND.t37 65.8183
R2670 VGND.n891 VGND.t37 65.8183
R2671 VGND.n887 VGND.t37 65.8183
R2672 VGND.n898 VGND.t37 65.8183
R2673 VGND.n884 VGND.t37 65.8183
R2674 VGND.n888 VGND.t37 65.8183
R2675 VGND.n1683 VGND.t37 65.8183
R2676 VGND.n449 VGND.t37 65.8183
R2677 VGND.n1701 VGND.t37 65.8183
R2678 VGND.t44 VGND.n1194 64.1729
R2679 VGND.n16 VGND.n13 63.0593
R2680 VGND.n1785 VGND.n1784 62.8048
R2681 VGND.n1784 VGND.n244 62.8048
R2682 VGND.n201 VGND.n178 62.4163
R2683 VGND.n1445 VGND.n1439 62.4163
R2684 VGND.n1437 VGND.n1436 62.4163
R2685 VGND.n1888 VGND.n180 62.4163
R2686 VGND.n1983 VGND.t6 62.1744
R2687 VGND.n1889 VGND.n179 58.4076
R2688 VGND.t44 VGND.n1192 57.8461
R2689 VGND.n965 VGND.t38 57.8461
R2690 VGND.n1385 VGND.t42 57.8461
R2691 VGND.t39 VGND.n1481 57.8461
R2692 VGND.t35 VGND.n345 57.8461
R2693 VGND.t33 VGND.n602 57.8461
R2694 VGND.t40 VGND.n713 57.8461
R2695 VGND.n905 VGND.t37 57.8461
R2696 VGND.n1993 VGND.t36 57.3918
R2697 VGND.n1215 VGND.n1194 56.6572
R2698 VGND.n1199 VGND.n1194 56.6572
R2699 VGND.n1004 VGND.t38 55.2026
R2700 VGND.t39 VGND.n1638 55.2026
R2701 VGND.t35 VGND.n322 55.2026
R2702 VGND.t33 VGND.n1309 55.2026
R2703 VGND.n1421 VGND.t42 55.2026
R2704 VGND.t40 VGND.n1157 55.2026
R2705 VGND.n1847 VGND.t43 55.2026
R2706 VGND.n939 VGND.t37 55.2026
R2707 VGND.n2006 VGND.n32 53.889
R2708 VGND.n1214 VGND.n1195 53.3664
R2709 VGND.n1210 VGND.n1196 53.3664
R2710 VGND.n1206 VGND.n1197 53.3664
R2711 VGND.n1202 VGND.n1198 53.3664
R2712 VGND.n1200 VGND.n1185 53.3664
R2713 VGND.n1245 VGND.n1193 53.3664
R2714 VGND.n1241 VGND.n1187 53.3664
R2715 VGND.n1230 VGND.n1188 53.3664
R2716 VGND.n1226 VGND.n1189 53.3664
R2717 VGND.n1222 VGND.n1190 53.3664
R2718 VGND.n1218 VGND.n1191 53.3664
R2719 VGND.n1253 VGND.n1183 53.3664
R2720 VGND.n1221 VGND.n1191 53.3664
R2721 VGND.n1225 VGND.n1190 53.3664
R2722 VGND.n1229 VGND.n1189 53.3664
R2723 VGND.n1233 VGND.n1188 53.3664
R2724 VGND.n1238 VGND.n1187 53.3664
R2725 VGND.n1242 VGND.n1193 53.3664
R2726 VGND.n1246 VGND.n1185 53.3664
R2727 VGND.n1211 VGND.n1195 53.3664
R2728 VGND.n1207 VGND.n1196 53.3664
R2729 VGND.n1203 VGND.n1197 53.3664
R2730 VGND.n1251 VGND.n1198 53.3664
R2731 VGND.n979 VGND.n763 53.3664
R2732 VGND.n978 VGND.n977 53.3664
R2733 VGND.n971 VGND.n765 53.3664
R2734 VGND.n970 VGND.n766 53.3664
R2735 VGND.n960 VGND.n770 53.3664
R2736 VGND.n958 VGND.n957 53.3664
R2737 VGND.n953 VGND.n773 53.3664
R2738 VGND.n951 VGND.n950 53.3664
R2739 VGND.n1007 VGND.n1006 53.3664
R2740 VGND.n786 VGND.n758 53.3664
R2741 VGND.n785 VGND.n784 53.3664
R2742 VGND.n782 VGND.n781 53.3664
R2743 VGND.n986 VGND.n985 53.3664
R2744 VGND.n988 VGND.n987 53.3664
R2745 VGND.n993 VGND.n992 53.3664
R2746 VGND.n996 VGND.n995 53.3664
R2747 VGND.n985 VGND.n984 53.3664
R2748 VGND.n987 VGND.n761 53.3664
R2749 VGND.n994 VGND.n993 53.3664
R2750 VGND.n995 VGND.n759 53.3664
R2751 VGND.n967 VGND.n766 53.3664
R2752 VGND.n972 VGND.n971 53.3664
R2753 VGND.n977 VGND.n976 53.3664
R2754 VGND.n980 VGND.n979 53.3664
R2755 VGND.n952 VGND.n951 53.3664
R2756 VGND.n773 VGND.n771 53.3664
R2757 VGND.n959 VGND.n958 53.3664
R2758 VGND.n770 VGND.n768 53.3664
R2759 VGND.n781 VGND.n774 53.3664
R2760 VGND.n784 VGND.n783 53.3664
R2761 VGND.n787 VGND.n786 53.3664
R2762 VGND.n1008 VGND.n1007 53.3664
R2763 VGND.n1399 VGND.n1359 53.3664
R2764 VGND.n1398 VGND.n1397 53.3664
R2765 VGND.n1391 VGND.n1361 53.3664
R2766 VGND.n1390 VGND.n1362 53.3664
R2767 VGND.n1380 VGND.n1366 53.3664
R2768 VGND.n1378 VGND.n1377 53.3664
R2769 VGND.n1373 VGND.n1370 53.3664
R2770 VGND.n1371 VGND.n257 53.3664
R2771 VGND.n1424 VGND.n1423 53.3664
R2772 VGND.n1762 VGND.n1761 53.3664
R2773 VGND.n1765 VGND.n1764 53.3664
R2774 VGND.n1768 VGND.n1767 53.3664
R2775 VGND.n1406 VGND.n1405 53.3664
R2776 VGND.n1408 VGND.n1407 53.3664
R2777 VGND.n1413 VGND.n1412 53.3664
R2778 VGND.n1416 VGND.n1415 53.3664
R2779 VGND.n1405 VGND.n1404 53.3664
R2780 VGND.n1407 VGND.n1357 53.3664
R2781 VGND.n1414 VGND.n1413 53.3664
R2782 VGND.n1415 VGND.n1355 53.3664
R2783 VGND.n1387 VGND.n1362 53.3664
R2784 VGND.n1392 VGND.n1391 53.3664
R2785 VGND.n1397 VGND.n1396 53.3664
R2786 VGND.n1400 VGND.n1399 53.3664
R2787 VGND.n1372 VGND.n1371 53.3664
R2788 VGND.n1370 VGND.n1367 53.3664
R2789 VGND.n1379 VGND.n1378 53.3664
R2790 VGND.n1366 VGND.n1364 53.3664
R2791 VGND.n1618 VGND.n1487 53.3664
R2792 VGND.n1614 VGND.n1476 53.3664
R2793 VGND.n1610 VGND.n1486 53.3664
R2794 VGND.n1606 VGND.n1479 53.3664
R2795 VGND.n1595 VGND.n1482 53.3664
R2796 VGND.n1591 VGND.n1483 53.3664
R2797 VGND.n1587 VGND.n1484 53.3664
R2798 VGND.n1583 VGND.n1485 53.3664
R2799 VGND.n1640 VGND.n1639 53.3664
R2800 VGND.n1540 VGND.n1477 53.3664
R2801 VGND.n1553 VGND.n1478 53.3664
R2802 VGND.n1535 VGND.n1480 53.3664
R2803 VGND.n1622 VGND.n1491 53.3664
R2804 VGND.n1623 VGND.n1490 53.3664
R2805 VGND.n1627 VGND.n1489 53.3664
R2806 VGND.n1631 VGND.n1488 53.3664
R2807 VGND.n1619 VGND.n1491 53.3664
R2808 VGND.n1626 VGND.n1490 53.3664
R2809 VGND.n1630 VGND.n1489 53.3664
R2810 VGND.n1492 VGND.n1488 53.3664
R2811 VGND.n1603 VGND.n1479 53.3664
R2812 VGND.n1607 VGND.n1486 53.3664
R2813 VGND.n1611 VGND.n1476 53.3664
R2814 VGND.n1615 VGND.n1487 53.3664
R2815 VGND.n1586 VGND.n1485 53.3664
R2816 VGND.n1590 VGND.n1484 53.3664
R2817 VGND.n1594 VGND.n1483 53.3664
R2818 VGND.n1598 VGND.n1482 53.3664
R2819 VGND.n1582 VGND.n1480 53.3664
R2820 VGND.n1534 VGND.n1478 53.3664
R2821 VGND.n1552 VGND.n1477 53.3664
R2822 VGND.n1639 VGND.n1475 53.3664
R2823 VGND.n382 VGND.n349 53.3664
R2824 VGND.n379 VGND.n343 53.3664
R2825 VGND.n375 VGND.n348 53.3664
R2826 VGND.n371 VGND.n344 53.3664
R2827 VGND.n360 VGND.n346 53.3664
R2828 VGND.n356 VGND.n347 53.3664
R2829 VGND.n402 VGND.n401 53.3664
R2830 VGND.n406 VGND.n340 53.3664
R2831 VGND.n434 VGND.n323 53.3664
R2832 VGND.n427 VGND.n327 53.3664
R2833 VGND.n420 VGND.n331 53.3664
R2834 VGND.n413 VGND.n335 53.3664
R2835 VGND.n400 VGND.n399 53.3664
R2836 VGND.n354 VGND.n352 53.3664
R2837 VGND.n394 VGND.n351 53.3664
R2838 VGND.n390 VGND.n350 53.3664
R2839 VGND.n400 VGND.n353 53.3664
R2840 VGND.n395 VGND.n352 53.3664
R2841 VGND.n391 VGND.n351 53.3664
R2842 VGND.n387 VGND.n350 53.3664
R2843 VGND.n368 VGND.n344 53.3664
R2844 VGND.n372 VGND.n348 53.3664
R2845 VGND.n376 VGND.n343 53.3664
R2846 VGND.n380 VGND.n349 53.3664
R2847 VGND.n403 VGND.n340 53.3664
R2848 VGND.n401 VGND.n342 53.3664
R2849 VGND.n359 VGND.n347 53.3664
R2850 VGND.n363 VGND.n346 53.3664
R2851 VGND.n407 VGND.n335 53.3664
R2852 VGND.n414 VGND.n331 53.3664
R2853 VGND.n421 VGND.n327 53.3664
R2854 VGND.n428 VGND.n323 53.3664
R2855 VGND.n647 VGND.n608 53.3664
R2856 VGND.n643 VGND.n597 53.3664
R2857 VGND.n639 VGND.n607 53.3664
R2858 VGND.n635 VGND.n600 53.3664
R2859 VGND.n624 VGND.n603 53.3664
R2860 VGND.n620 VGND.n604 53.3664
R2861 VGND.n616 VGND.n605 53.3664
R2862 VGND.n1294 VGND.n606 53.3664
R2863 VGND.n1311 VGND.n1310 53.3664
R2864 VGND.n1276 VGND.n598 53.3664
R2865 VGND.n1284 VGND.n599 53.3664
R2866 VGND.n1292 VGND.n601 53.3664
R2867 VGND.n651 VGND.n612 53.3664
R2868 VGND.n652 VGND.n611 53.3664
R2869 VGND.n656 VGND.n610 53.3664
R2870 VGND.n660 VGND.n609 53.3664
R2871 VGND.n648 VGND.n612 53.3664
R2872 VGND.n655 VGND.n611 53.3664
R2873 VGND.n659 VGND.n610 53.3664
R2874 VGND.n613 VGND.n609 53.3664
R2875 VGND.n632 VGND.n600 53.3664
R2876 VGND.n636 VGND.n607 53.3664
R2877 VGND.n640 VGND.n597 53.3664
R2878 VGND.n644 VGND.n608 53.3664
R2879 VGND.n615 VGND.n606 53.3664
R2880 VGND.n619 VGND.n605 53.3664
R2881 VGND.n623 VGND.n604 53.3664
R2882 VGND.n627 VGND.n603 53.3664
R2883 VGND.n1295 VGND.n601 53.3664
R2884 VGND.n1291 VGND.n599 53.3664
R2885 VGND.n1283 VGND.n598 53.3664
R2886 VGND.n1310 VGND.n596 53.3664
R2887 VGND.n1769 VGND.n1768 53.3664
R2888 VGND.n1766 VGND.n1765 53.3664
R2889 VGND.n1763 VGND.n1762 53.3664
R2890 VGND.n1423 VGND.n260 53.3664
R2891 VGND.n1104 VGND.n719 53.3664
R2892 VGND.n1108 VGND.n708 53.3664
R2893 VGND.n1112 VGND.n718 53.3664
R2894 VGND.n1116 VGND.n711 53.3664
R2895 VGND.n1127 VGND.n714 53.3664
R2896 VGND.n1131 VGND.n715 53.3664
R2897 VGND.n1135 VGND.n716 53.3664
R2898 VGND.n1139 VGND.n717 53.3664
R2899 VGND.n1159 VGND.n1158 53.3664
R2900 VGND.n1068 VGND.n709 53.3664
R2901 VGND.n1076 VGND.n710 53.3664
R2902 VGND.n1086 VGND.n712 53.3664
R2903 VGND.n1100 VGND.n723 53.3664
R2904 VGND.n1099 VGND.n722 53.3664
R2905 VGND.n1095 VGND.n721 53.3664
R2906 VGND.n1091 VGND.n720 53.3664
R2907 VGND.n1103 VGND.n723 53.3664
R2908 VGND.n1096 VGND.n722 53.3664
R2909 VGND.n1092 VGND.n721 53.3664
R2910 VGND.n724 VGND.n720 53.3664
R2911 VGND.n1119 VGND.n711 53.3664
R2912 VGND.n1115 VGND.n718 53.3664
R2913 VGND.n1111 VGND.n708 53.3664
R2914 VGND.n1107 VGND.n719 53.3664
R2915 VGND.n1136 VGND.n717 53.3664
R2916 VGND.n1132 VGND.n716 53.3664
R2917 VGND.n1128 VGND.n715 53.3664
R2918 VGND.n1124 VGND.n714 53.3664
R2919 VGND.n1138 VGND.n712 53.3664
R2920 VGND.n1085 VGND.n710 53.3664
R2921 VGND.n1075 VGND.n709 53.3664
R2922 VGND.n1158 VGND.n707 53.3664
R2923 VGND.n1252 VGND.n1178 53.3664
R2924 VGND.n1824 VGND.n213 53.3664
R2925 VGND.n1823 VGND.n1822 53.3664
R2926 VGND.n1816 VGND.n1815 53.3664
R2927 VGND.n1810 VGND.n216 53.3664
R2928 VGND.n1807 VGND.n1806 53.3664
R2929 VGND.n1802 VGND.n221 53.3664
R2930 VGND.n1800 VGND.n1799 53.3664
R2931 VGND.n1795 VGND.n224 53.3664
R2932 VGND.n1852 VGND.n1851 53.3664
R2933 VGND.n235 VGND.n208 53.3664
R2934 VGND.n237 VGND.n225 53.3664
R2935 VGND.n1794 VGND.n1793 53.3664
R2936 VGND.n1831 VGND.n1830 53.3664
R2937 VGND.n1833 VGND.n1832 53.3664
R2938 VGND.n1838 VGND.n1837 53.3664
R2939 VGND.n1841 VGND.n1840 53.3664
R2940 VGND.n1830 VGND.n1829 53.3664
R2941 VGND.n1832 VGND.n211 53.3664
R2942 VGND.n1839 VGND.n1838 53.3664
R2943 VGND.n1840 VGND.n209 53.3664
R2944 VGND.n1811 VGND.n1810 53.3664
R2945 VGND.n1817 VGND.n1816 53.3664
R2946 VGND.n1822 VGND.n1821 53.3664
R2947 VGND.n1825 VGND.n1824 53.3664
R2948 VGND.n224 VGND.n222 53.3664
R2949 VGND.n1801 VGND.n1800 53.3664
R2950 VGND.n221 VGND.n219 53.3664
R2951 VGND.n1808 VGND.n1807 53.3664
R2952 VGND.n236 VGND.n235 53.3664
R2953 VGND.n1853 VGND.n1852 53.3664
R2954 VGND.n922 VGND.n921 53.3664
R2955 VGND.n915 VGND.n878 53.3664
R2956 VGND.n914 VGND.n913 53.3664
R2957 VGND.n907 VGND.n880 53.3664
R2958 VGND.n900 VGND.n884 53.3664
R2959 VGND.n898 VGND.n897 53.3664
R2960 VGND.n893 VGND.n887 53.3664
R2961 VGND.n891 VGND.n890 53.3664
R2962 VGND.n1701 VGND.n1700 53.3664
R2963 VGND.n449 VGND.n310 53.3664
R2964 VGND.n1684 VGND.n1683 53.3664
R2965 VGND.n888 VGND.n451 53.3664
R2966 VGND.n923 VGND.n876 53.3664
R2967 VGND.n929 VGND.n928 53.3664
R2968 VGND.n932 VGND.n931 53.3664
R2969 VGND.n937 VGND.n936 53.3664
R2970 VGND.n924 VGND.n923 53.3664
R2971 VGND.n930 VGND.n929 53.3664
R2972 VGND.n931 VGND.n874 53.3664
R2973 VGND.n938 VGND.n937 53.3664
R2974 VGND.n908 VGND.n907 53.3664
R2975 VGND.n913 VGND.n912 53.3664
R2976 VGND.n916 VGND.n915 53.3664
R2977 VGND.n921 VGND.n920 53.3664
R2978 VGND.n892 VGND.n891 53.3664
R2979 VGND.n887 VGND.n885 53.3664
R2980 VGND.n899 VGND.n898 53.3664
R2981 VGND.n884 VGND.n882 53.3664
R2982 VGND.n889 VGND.n888 53.3664
R2983 VGND.n1683 VGND.n1682 53.3664
R2984 VGND.n450 VGND.n449 53.3664
R2985 VGND.n1702 VGND.n1701 53.3664
R2986 VGND.n1863 VGND.n1862 52.1579
R2987 VGND.n1864 VGND.t24 52.1579
R2988 VGND.n1877 VGND.t41 50.0716
R2989 VGND.t1 VGND.n489 47.8266
R2990 VGND.n1866 VGND.n1865 41.7862
R2991 VGND.n1865 VGND.n1864 41.7862
R2992 VGND.n195 VGND.t31 40.8142
R2993 VGND.n6 VGND.t20 40.8142
R2994 VGND.n1999 VGND.t41 40.4386
R2995 VGND.n195 VGND 33.275
R2996 VGND.n6 VGND 33.275
R2997 VGND.n1859 VGND.t25 31.295
R2998 VGND.n1785 VGND.n243 31.2703
R2999 VGND.n77 VGND.t5 31.0875
R3000 VGND.n1236 VGND.n1235 23.6449
R3001 VGND.n963 VGND.n767 23.6449
R3002 VGND.n1383 VGND.n1363 23.6449
R3003 VGND.n1601 VGND.n1600 23.6449
R3004 VGND.n366 VGND.n365 23.6449
R3005 VGND.n630 VGND.n629 23.6449
R3006 VGND.n1122 VGND.n1121 23.6449
R3007 VGND.n1812 VGND.n217 23.6449
R3008 VGND.n903 VGND.n881 23.6449
R3009 VGND.n1781 VGND.n1779 22.9336
R3010 VGND.n1880 VGND.n185 22.094
R3011 VGND.n1440 VGND.t0 20.8635
R3012 VGND.n1789 VGND.n200 18.4117
R3013 VGND.n1438 VGND.n1437 17.555
R3014 VGND.n1782 VGND.n1781 17.5309
R3015 VGND.n1217 VGND.n1216 17.4227
R3016 VGND.n983 VGND.n982 17.4227
R3017 VGND.n1403 VGND.n1402 17.4227
R3018 VGND.n1620 VGND.n1617 17.4227
R3019 VGND.n384 VGND.n383 17.4227
R3020 VGND.n649 VGND.n646 17.4227
R3021 VGND.n1105 VGND.n1102 17.4227
R3022 VGND.n1828 VGND.n1827 17.4227
R3023 VGND.n925 VGND.n877 17.4227
R3024 VGND.n441 VGND.n103 16.9587
R3025 VGND.n1235 VGND.n1232 16.0005
R3026 VGND.n1232 VGND.n1231 16.0005
R3027 VGND.n1231 VGND.n1228 16.0005
R3028 VGND.n1228 VGND.n1227 16.0005
R3029 VGND.n1227 VGND.n1224 16.0005
R3030 VGND.n1224 VGND.n1223 16.0005
R3031 VGND.n1223 VGND.n1220 16.0005
R3032 VGND.n1220 VGND.n1219 16.0005
R3033 VGND.n1249 VGND.n1217 16.0005
R3034 VGND.n1249 VGND.n1248 16.0005
R3035 VGND.n1248 VGND.n1247 16.0005
R3036 VGND.n1247 VGND.n1244 16.0005
R3037 VGND.n1244 VGND.n1243 16.0005
R3038 VGND.n1240 VGND.n1239 16.0005
R3039 VGND.n1239 VGND.n1236 16.0005
R3040 VGND.n1216 VGND.n1213 16.0005
R3041 VGND.n1213 VGND.n1212 16.0005
R3042 VGND.n1212 VGND.n1209 16.0005
R3043 VGND.n1209 VGND.n1208 16.0005
R3044 VGND.n1208 VGND.n1205 16.0005
R3045 VGND.n1205 VGND.n1204 16.0005
R3046 VGND.n1204 VGND.n1201 16.0005
R3047 VGND.n1201 VGND.n1176 16.0005
R3048 VGND.n983 VGND.n762 16.0005
R3049 VGND.n989 VGND.n762 16.0005
R3050 VGND.n990 VGND.n989 16.0005
R3051 VGND.n991 VGND.n990 16.0005
R3052 VGND.n991 VGND.n760 16.0005
R3053 VGND.n997 VGND.n760 16.0005
R3054 VGND.n998 VGND.n997 16.0005
R3055 VGND.n1002 VGND.n998 16.0005
R3056 VGND.n982 VGND.n981 16.0005
R3057 VGND.n981 VGND.n764 16.0005
R3058 VGND.n975 VGND.n764 16.0005
R3059 VGND.n975 VGND.n974 16.0005
R3060 VGND.n974 VGND.n973 16.0005
R3061 VGND.n969 VGND.n968 16.0005
R3062 VGND.n968 VGND.n767 16.0005
R3063 VGND.n963 VGND.n962 16.0005
R3064 VGND.n962 VGND.n961 16.0005
R3065 VGND.n961 VGND.n769 16.0005
R3066 VGND.n956 VGND.n769 16.0005
R3067 VGND.n956 VGND.n955 16.0005
R3068 VGND.n955 VGND.n954 16.0005
R3069 VGND.n954 VGND.n772 16.0005
R3070 VGND.n949 VGND.n772 16.0005
R3071 VGND.n1403 VGND.n1358 16.0005
R3072 VGND.n1409 VGND.n1358 16.0005
R3073 VGND.n1410 VGND.n1409 16.0005
R3074 VGND.n1411 VGND.n1410 16.0005
R3075 VGND.n1411 VGND.n1356 16.0005
R3076 VGND.n1417 VGND.n1356 16.0005
R3077 VGND.n1418 VGND.n1417 16.0005
R3078 VGND.n1419 VGND.n1418 16.0005
R3079 VGND.n1402 VGND.n1401 16.0005
R3080 VGND.n1401 VGND.n1360 16.0005
R3081 VGND.n1395 VGND.n1360 16.0005
R3082 VGND.n1395 VGND.n1394 16.0005
R3083 VGND.n1394 VGND.n1393 16.0005
R3084 VGND.n1389 VGND.n1388 16.0005
R3085 VGND.n1388 VGND.n1363 16.0005
R3086 VGND.n1383 VGND.n1382 16.0005
R3087 VGND.n1382 VGND.n1381 16.0005
R3088 VGND.n1381 VGND.n1365 16.0005
R3089 VGND.n1376 VGND.n1365 16.0005
R3090 VGND.n1376 VGND.n1375 16.0005
R3091 VGND.n1375 VGND.n1374 16.0005
R3092 VGND.n1374 VGND.n1369 16.0005
R3093 VGND.n1369 VGND.n1368 16.0005
R3094 VGND.n1621 VGND.n1620 16.0005
R3095 VGND.n1624 VGND.n1621 16.0005
R3096 VGND.n1625 VGND.n1624 16.0005
R3097 VGND.n1628 VGND.n1625 16.0005
R3098 VGND.n1629 VGND.n1628 16.0005
R3099 VGND.n1632 VGND.n1629 16.0005
R3100 VGND.n1633 VGND.n1632 16.0005
R3101 VGND.n1636 VGND.n1633 16.0005
R3102 VGND.n1617 VGND.n1616 16.0005
R3103 VGND.n1616 VGND.n1613 16.0005
R3104 VGND.n1613 VGND.n1612 16.0005
R3105 VGND.n1612 VGND.n1609 16.0005
R3106 VGND.n1609 VGND.n1608 16.0005
R3107 VGND.n1605 VGND.n1604 16.0005
R3108 VGND.n1604 VGND.n1601 16.0005
R3109 VGND.n1600 VGND.n1597 16.0005
R3110 VGND.n1597 VGND.n1596 16.0005
R3111 VGND.n1596 VGND.n1593 16.0005
R3112 VGND.n1593 VGND.n1592 16.0005
R3113 VGND.n1592 VGND.n1589 16.0005
R3114 VGND.n1589 VGND.n1588 16.0005
R3115 VGND.n1588 VGND.n1585 16.0005
R3116 VGND.n1585 VGND.n1584 16.0005
R3117 VGND.n398 VGND.n384 16.0005
R3118 VGND.n398 VGND.n397 16.0005
R3119 VGND.n397 VGND.n396 16.0005
R3120 VGND.n396 VGND.n393 16.0005
R3121 VGND.n393 VGND.n392 16.0005
R3122 VGND.n392 VGND.n389 16.0005
R3123 VGND.n389 VGND.n388 16.0005
R3124 VGND.n388 VGND.n385 16.0005
R3125 VGND.n383 VGND.n381 16.0005
R3126 VGND.n381 VGND.n378 16.0005
R3127 VGND.n378 VGND.n377 16.0005
R3128 VGND.n377 VGND.n374 16.0005
R3129 VGND.n374 VGND.n373 16.0005
R3130 VGND.n370 VGND.n369 16.0005
R3131 VGND.n369 VGND.n366 16.0005
R3132 VGND.n365 VGND.n362 16.0005
R3133 VGND.n362 VGND.n361 16.0005
R3134 VGND.n361 VGND.n358 16.0005
R3135 VGND.n358 VGND.n357 16.0005
R3136 VGND.n357 VGND.n355 16.0005
R3137 VGND.n355 VGND.n341 16.0005
R3138 VGND.n404 VGND.n341 16.0005
R3139 VGND.n405 VGND.n404 16.0005
R3140 VGND.n650 VGND.n649 16.0005
R3141 VGND.n653 VGND.n650 16.0005
R3142 VGND.n654 VGND.n653 16.0005
R3143 VGND.n657 VGND.n654 16.0005
R3144 VGND.n658 VGND.n657 16.0005
R3145 VGND.n661 VGND.n658 16.0005
R3146 VGND.n662 VGND.n661 16.0005
R3147 VGND.n1307 VGND.n662 16.0005
R3148 VGND.n646 VGND.n645 16.0005
R3149 VGND.n645 VGND.n642 16.0005
R3150 VGND.n642 VGND.n641 16.0005
R3151 VGND.n641 VGND.n638 16.0005
R3152 VGND.n638 VGND.n637 16.0005
R3153 VGND.n634 VGND.n633 16.0005
R3154 VGND.n633 VGND.n630 16.0005
R3155 VGND.n629 VGND.n626 16.0005
R3156 VGND.n626 VGND.n625 16.0005
R3157 VGND.n625 VGND.n622 16.0005
R3158 VGND.n622 VGND.n621 16.0005
R3159 VGND.n621 VGND.n618 16.0005
R3160 VGND.n618 VGND.n617 16.0005
R3161 VGND.n617 VGND.n614 16.0005
R3162 VGND.n614 VGND.n584 16.0005
R3163 VGND.n1102 VGND.n1101 16.0005
R3164 VGND.n1101 VGND.n1098 16.0005
R3165 VGND.n1098 VGND.n1097 16.0005
R3166 VGND.n1097 VGND.n1094 16.0005
R3167 VGND.n1094 VGND.n1093 16.0005
R3168 VGND.n1093 VGND.n1090 16.0005
R3169 VGND.n1090 VGND.n725 16.0005
R3170 VGND.n1155 VGND.n725 16.0005
R3171 VGND.n1106 VGND.n1105 16.0005
R3172 VGND.n1109 VGND.n1106 16.0005
R3173 VGND.n1110 VGND.n1109 16.0005
R3174 VGND.n1113 VGND.n1110 16.0005
R3175 VGND.n1114 VGND.n1113 16.0005
R3176 VGND.n1118 VGND.n1117 16.0005
R3177 VGND.n1121 VGND.n1118 16.0005
R3178 VGND.n1125 VGND.n1122 16.0005
R3179 VGND.n1126 VGND.n1125 16.0005
R3180 VGND.n1129 VGND.n1126 16.0005
R3181 VGND.n1130 VGND.n1129 16.0005
R3182 VGND.n1133 VGND.n1130 16.0005
R3183 VGND.n1134 VGND.n1133 16.0005
R3184 VGND.n1137 VGND.n1134 16.0005
R3185 VGND.n1140 VGND.n1137 16.0005
R3186 VGND.n1828 VGND.n212 16.0005
R3187 VGND.n1834 VGND.n212 16.0005
R3188 VGND.n1835 VGND.n1834 16.0005
R3189 VGND.n1836 VGND.n1835 16.0005
R3190 VGND.n1836 VGND.n210 16.0005
R3191 VGND.n1842 VGND.n210 16.0005
R3192 VGND.n1843 VGND.n1842 16.0005
R3193 VGND.n1845 VGND.n1843 16.0005
R3194 VGND.n1827 VGND.n1826 16.0005
R3195 VGND.n1826 VGND.n214 16.0005
R3196 VGND.n1820 VGND.n214 16.0005
R3197 VGND.n1820 VGND.n1819 16.0005
R3198 VGND.n1819 VGND.n1818 16.0005
R3199 VGND.n1814 VGND.n1813 16.0005
R3200 VGND.n1813 VGND.n1812 16.0005
R3201 VGND.n218 VGND.n217 16.0005
R3202 VGND.n1805 VGND.n218 16.0005
R3203 VGND.n1805 VGND.n1804 16.0005
R3204 VGND.n1804 VGND.n1803 16.0005
R3205 VGND.n1803 VGND.n220 16.0005
R3206 VGND.n1798 VGND.n220 16.0005
R3207 VGND.n1798 VGND.n1797 16.0005
R3208 VGND.n1797 VGND.n1796 16.0005
R3209 VGND.n926 VGND.n925 16.0005
R3210 VGND.n927 VGND.n926 16.0005
R3211 VGND.n927 VGND.n875 16.0005
R3212 VGND.n933 VGND.n875 16.0005
R3213 VGND.n934 VGND.n933 16.0005
R3214 VGND.n935 VGND.n934 16.0005
R3215 VGND.n935 VGND.n873 16.0005
R3216 VGND.n941 VGND.n873 16.0005
R3217 VGND.n919 VGND.n877 16.0005
R3218 VGND.n919 VGND.n918 16.0005
R3219 VGND.n918 VGND.n917 16.0005
R3220 VGND.n917 VGND.n879 16.0005
R3221 VGND.n911 VGND.n879 16.0005
R3222 VGND.n910 VGND.n909 16.0005
R3223 VGND.n909 VGND.n881 16.0005
R3224 VGND.n903 VGND.n902 16.0005
R3225 VGND.n902 VGND.n901 16.0005
R3226 VGND.n901 VGND.n883 16.0005
R3227 VGND.n896 VGND.n883 16.0005
R3228 VGND.n896 VGND.n895 16.0005
R3229 VGND.n895 VGND.n894 16.0005
R3230 VGND.n894 VGND.n886 16.0005
R3231 VGND.n886 VGND.n462 16.0005
R3232 VGND.n1796 VGND.n223 15.9482
R3233 VGND.n1219 VGND.n1177 14.592
R3234 VGND.n949 VGND.n948 13.6894
R3235 VGND.n1584 VGND.n276 13.6894
R3236 VGND.n405 VGND.n281 13.6894
R3237 VGND.n1320 VGND.n584 13.6894
R3238 VGND.n1142 VGND.n1140 13.6894
R3239 VGND.n1671 VGND.n462 13.6894
R3240 VGND.n1936 VGND.n103 13.0453
R3241 VGND.n1240 VGND 12.9783
R3242 VGND.n969 VGND 12.9783
R3243 VGND.n1389 VGND 12.9783
R3244 VGND.n1605 VGND 12.9783
R3245 VGND.n370 VGND 12.9783
R3246 VGND.n634 VGND 12.9783
R3247 VGND.n1117 VGND 12.9783
R3248 VGND.n1814 VGND 12.9783
R3249 VGND VGND.n910 12.9783
R3250 VGND.n1912 VGND.n110 11.9733
R3251 VGND.n17 VGND 11.889
R3252 VGND.n2020 VGND.n2019 11.8659
R3253 VGND.t32 VGND.n1857 10.432
R3254 VGND.n229 VGND.t18 10.432
R3255 VGND.n1002 VGND.n1001 10.3116
R3256 VGND.n1636 VGND.n1635 10.3116
R3257 VGND.n385 VGND.n320 10.3116
R3258 VGND.n1307 VGND.n1306 10.3116
R3259 VGND.n1155 VGND.n1154 10.3116
R3260 VGND.n1845 VGND.n1844 10.3116
R3261 VGND.n945 VGND.n941 10.3116
R3262 VGND.n28 VGND 9.76137
R3263 VGND.n2009 VGND 9.60535
R3264 VGND.n2011 VGND.n2010 9.46425
R3265 VGND.n29 VGND.n28 9.37675
R3266 VGND.n27 VGND.n14 9.3005
R3267 VGND.n26 VGND.n25 9.3005
R3268 VGND.n24 VGND.n15 9.3005
R3269 VGND.n23 VGND.n22 9.3005
R3270 VGND.n21 VGND.n20 9.3005
R3271 VGND.n19 VGND.n17 9.3005
R3272 VGND.n2006 VGND.n2005 9.3005
R3273 VGND.n2021 VGND.n2020 9.3005
R3274 VGND.n1782 VGND.n199 9.18311
R3275 VGND.n19 VGND.n18 9.17685
R3276 VGND.n2014 VGND.n2013 9.00464
R3277 VGND.n1779 VGND.n1778 8.65464
R3278 VGND.n2012 VGND.n2008 8.46398
R3279 VGND.n18 VGND.n10 8.1203
R3280 VGND.n1444 VGND.n1348 8.08753
R3281 VGND.n1750 VGND.n246 8.08753
R3282 VGND.n1435 VGND.n1348 8.03397
R3283 VGND.n1182 VGND.n182 7.79537
R3284 VGND.n1020 VGND.n736 7.61523
R3285 VGND.n1734 VGND.n283 7.51963
R3286 VGND.n1167 VGND.n696 6.96898
R3287 VGND.n1736 VGND.n278 6.64531
R3288 VGND.n1883 VGND.t30 6.25939
R3289 VGND.n2017 VGND.t22 6.01768
R3290 VGND.n1327 VGND.n2 588.939
R3291 VGND.n114 VGND.t34 5.98689
R3292 VGND.n1924 VGND.n116 5.98689
R3293 VGND.n946 VGND.n872 5.90608
R3294 VGND.n1751 VGND.n1750 5.51682
R3295 VGND.n1435 VGND.n1434 5.4097
R3296 VGND.t36 VGND.n0 3.47289
R3297 VGND.n1791 VGND.n223 5.1456
R3298 VGND.n1444 VGND.n1443 5.14192
R3299 VGND.n1752 VGND.n1751 5.14192
R3300 VGND.n469 VGND.n89 4.88894
R3301 VGND.n1971 VGND.n1970 4.88894
R3302 VGND.n1732 VGND.n1731 4.87323
R3303 VGND.n1434 VGND.n1433 4.82058
R3304 VGND.n1752 VGND.n256 4.82058
R3305 VGND.n2007 VGND.n5 4.78596
R3306 VGND.n2012 VGND 4.67427
R3307 VGND.n1651 VGND.n554 4.04261
R3308 VGND.n1650 VGND.n1649 4.04261
R3309 VGND.n1023 VGND.n734 4.04261
R3310 VGND.n1029 VGND.n734 4.04261
R3311 VGND.n1030 VGND.n1029 4.04261
R3312 VGND.n1032 VGND.n732 4.04261
R3313 VGND.n1038 VGND.n732 4.04261
R3314 VGND.n1039 VGND.n1038 4.04261
R3315 VGND.n1040 VGND.n1039 4.04261
R3316 VGND.n1040 VGND.n730 4.04261
R3317 VGND.n1046 VGND.n730 4.04261
R3318 VGND.n1914 VGND.n154 3.98871
R3319 VGND.n669 VGND.n668 3.98871
R3320 VGND.n44 VGND.n43 3.98666
R3321 VGND.n44 VGND.n34 3.98666
R3322 VGND.n2002 VGND.n35 3.98666
R3323 VGND.n1171 VGND.n1169 3.98666
R3324 VGND.n1172 VGND.n1171 3.98666
R3325 VGND.n1175 VGND.n1172 3.98666
R3326 VGND.n1271 VGND.n1268 3.98666
R3327 VGND.n1268 VGND.n1267 3.98666
R3328 VGND.n1267 VGND.n1264 3.98666
R3329 VGND.n1264 VGND.n1263 3.98666
R3330 VGND.n1263 VGND.n1260 3.98666
R3331 VGND.n1260 VGND.n1259 3.98666
R3332 VGND.n749 VGND.n35 3.97863
R3333 VGND.n1023 VGND.n1022 3.83497
R3334 VGND.n1730 VGND.n287 3.81507
R3335 VGND.n290 VGND.n287 3.81507
R3336 VGND.n1723 VGND.n290 3.81507
R3337 VGND.n1723 VGND.n284 3.81507
R3338 VGND.n291 VGND.n285 3.81507
R3339 VGND.n1716 VGND.n291 3.81507
R3340 VGND.n1716 VGND.n1715 3.81507
R3341 VGND.n1715 VGND.n1714 3.81507
R3342 VGND.n1509 VGND.n1504 3.81507
R3343 VGND.n1510 VGND.n1509 3.81507
R3344 VGND.n1511 VGND.n1510 3.81507
R3345 VGND.n1511 VGND.n279 3.81507
R3346 VGND.n1518 VGND.n280 3.81507
R3347 VGND.n1519 VGND.n1518 3.81507
R3348 VGND.n1519 VGND.n1497 3.81507
R3349 VGND.n1526 VGND.n1497 3.81507
R3350 VGND.n1527 VGND.n1526 3.81507
R3351 VGND.n1573 VGND.n1572 3.81507
R3352 VGND.n1572 VGND.n1569 3.81507
R3353 VGND.n1569 VGND.n1568 3.81507
R3354 VGND.n1568 VGND.n275 3.81507
R3355 VGND.n1741 VGND.n1738 3.81507
R3356 VGND.n1742 VGND.n1741 3.81507
R3357 VGND.n1745 VGND.n1742 3.81507
R3358 VGND.n1746 VGND.n1745 3.81507
R3359 VGND.n1749 VGND.n1746 3.81507
R3360 VGND.n1714 VGND.n293 3.80766
R3361 VGND.n1169 VGND.n1168 3.80391
R3362 VGND.n1048 VGND.n696 3.77815
R3363 VGND.n1731 VGND.n286 3.74595
R3364 VGND.n1663 VGND.n1662 3.65764
R3365 VGND.n1938 VGND.n100 3.65764
R3366 VGND.n1504 VGND.n1503 3.6372
R3367 VGND.n1574 VGND.n1573 3.6372
R3368 VGND.n2022 VGND.n2021 3.63197
R3369 VGND.n1047 VGND.n1046 3.62257
R3370 VGND.n2007 VGND.n2006 3.52535
R3371 VGND.n486 VGND.n286 3.49141
R3372 VGND.n1528 VGND.n1527 3.36297
R3373 VGND.n1964 VGND.n72 3.27323
R3374 VGND.n1964 VGND.n1963 3.27323
R3375 VGND.n1963 VGND.n1962 3.27323
R3376 VGND.n1962 VGND.n80 3.27323
R3377 VGND.n1956 VGND.n80 3.27323
R3378 VGND.n1956 VGND.n1955 3.27323
R3379 VGND.n1954 VGND.n84 3.27323
R3380 VGND.n1948 VGND.n84 3.27323
R3381 VGND.n1948 VGND.n1947 3.27323
R3382 VGND.n1947 VGND.n1946 3.27323
R3383 VGND.n474 VGND.n472 3.27323
R3384 VGND.n503 VGND.n474 3.27323
R3385 VGND.n503 VGND.n502 3.27323
R3386 VGND.n502 VGND.n501 3.27323
R3387 VGND.n501 VGND.n475 3.27323
R3388 VGND.n495 VGND.n475 3.27323
R3389 VGND.n494 VGND.n493 3.27323
R3390 VGND.n493 VGND.n480 3.27323
R3391 VGND.n487 VGND.n480 3.27323
R3392 VGND.n487 VGND.n486 3.27323
R3393 VGND.n1995 VGND.n59 3.27323
R3394 VGND.n1989 VGND.n1988 3.27323
R3395 VGND.n1988 VGND.n1987 3.27323
R3396 VGND.n1987 VGND.n64 3.27323
R3397 VGND.n1981 VGND.n64 3.27323
R3398 VGND.n1980 VGND.n1979 3.27323
R3399 VGND.n1979 VGND.n67 3.27323
R3400 VGND.n1973 VGND.n67 3.27323
R3401 VGND.n1973 VGND.n1972 3.27323
R3402 VGND.n750 VGND.n749 3.26396
R3403 VGND.n1736 VGND.n277 3.25296
R3404 VGND.n1709 VGND.n293 3.14804
R3405 VGND.n1048 VGND.n1047 3.0813
R3406 VGND.n1734 VGND.n282 3.0781
R3407 VGND.n2012 VGND.n2011 3.06509
R3408 VGND.n1735 VGND.n279 3.05216
R3409 VGND.n751 VGND.n750 3.04639
R3410 VGND.n1886 VGND.n181 3.02595
R3411 VGND.n1243 VGND 3.02272
R3412 VGND.n973 VGND 3.02272
R3413 VGND.n1393 VGND 3.02272
R3414 VGND.n1608 VGND 3.02272
R3415 VGND.n373 VGND 3.02272
R3416 VGND.n637 VGND 3.02272
R3417 VGND.n1114 VGND 3.02272
R3418 VGND.n1818 VGND 3.02272
R3419 VGND.n911 VGND 3.02272
R3420 VGND.n751 VGND.n736 3.01013
R3421 VGND.n1 VGND.t41 2.96735
R3422 VGND.n1863 VGND.n1 0.014425
R3423 VGND.n3 VGND.t34 1.00003
R3424 VGND.n1709 VGND.n282 2.9382
R3425 VGND.n1528 VGND.n277 2.9382
R3426 VGND.n198 VGND.n197 2.92738
R3427 VGND VGND.n1954 2.90959
R3428 VGND VGND.n494 2.90959
R3429 VGND VGND.n1980 2.90959
R3430 VGND.n1463 VGND.n555 2.89497
R3431 VGND.n1463 VGND.n559 2.89497
R3432 VGND.n1330 VGND.n559 2.89497
R3433 VGND.n1456 VGND.n1330 2.89497
R3434 VGND.n1456 VGND.n1455 2.89497
R3435 VGND.n1455 VGND.n1454 2.89497
R3436 VGND.n1454 VGND.n1339 2.89497
R3437 VGND.n1449 VGND.n1339 2.89497
R3438 VGND.n1449 VGND.n1448 2.89497
R3439 VGND.n1448 VGND.n1447 2.89497
R3440 VGND.n511 VGND.n469 2.89497
R3441 VGND.n514 VGND.n511 2.89497
R3442 VGND.n514 VGND.n467 2.89497
R3443 VGND.n520 VGND.n467 2.89497
R3444 VGND.n523 VGND.n520 2.89497
R3445 VGND.n526 VGND.n523 2.89497
R3446 VGND.n526 VGND.n465 2.89497
R3447 VGND.n533 VGND.n465 2.89497
R3448 VGND.n534 VGND.n533 2.89497
R3449 VGND.n536 VGND.n534 2.89497
R3450 VGND.n1970 VGND.n74 2.89497
R3451 VGND.n838 VGND.n74 2.89497
R3452 VGND.n841 VGND.n838 2.89497
R3453 VGND.n841 VGND.n832 2.89497
R3454 VGND.n847 VGND.n832 2.89497
R3455 VGND.n848 VGND.n847 2.89497
R3456 VGND.n851 VGND.n848 2.89497
R3457 VGND.n851 VGND.n830 2.89497
R3458 VGND.n857 VGND.n830 2.89497
R3459 VGND.n857 VGND.n822 2.89497
R3460 VGND.n163 VGND.n157 2.89497
R3461 VGND.n1906 VGND.n163 2.89497
R3462 VGND.n1906 VGND.n1905 2.89497
R3463 VGND.n1905 VGND.n1904 2.89497
R3464 VGND.n1904 VGND.n166 2.89497
R3465 VGND.n169 VGND.n166 2.89497
R3466 VGND.n1895 VGND.n169 2.89497
R3467 VGND.n1895 VGND.n1894 2.89497
R3468 VGND.n1894 VGND.n1893 2.89497
R3469 VGND.n1893 VGND.n174 2.89497
R3470 VGND.n1887 VGND.n174 2.89497
R3471 VGND.n864 VGND.n822 2.89028
R3472 VGND.n1661 VGND.n540 2.8805
R3473 VGND.n568 VGND.n540 2.8805
R3474 VGND.n569 VGND.n568 2.8805
R3475 VGND.n574 VGND.n569 2.8805
R3476 VGND.n575 VGND.n574 2.8805
R3477 VGND.n578 VGND.n575 2.8805
R3478 VGND.n578 VGND.n550 2.8805
R3479 VGND.n1655 VGND.n550 2.8805
R3480 VGND.n1655 VGND.n1654 2.8805
R3481 VGND.n1654 VGND.n1653 2.8805
R3482 VGND.n1272 VGND.n1271 2.87939
R3483 VGND.n536 VGND.n100 2.86281
R3484 VGND.n1783 VGND.n226 2.82403
R3485 VGND.n1731 VGND.n1730 2.79785
R3486 VGND.n1886 VGND.n1885 2.79323
R3487 VGND.n1032 VGND.n1031 2.74015
R3488 VGND.n1649 VGND.n556 2.72218
R3489 VGND.n1433 VGND.n1351 2.67832
R3490 VGND.n1425 VGND.n1354 2.67832
R3491 VGND.n1427 VGND.n1426 2.67832
R3492 VGND.n1760 VGND.n261 2.67832
R3493 VGND.n258 VGND.n247 2.67832
R3494 VGND.n1777 VGND.n248 2.67832
R3495 VGND.n255 VGND.n254 2.67832
R3496 VGND.n1771 VGND.n1770 2.67832
R3497 VGND.n674 VGND.n673 2.66829
R3498 VGND.n1849 VGND.n203 2.6561
R3499 VGND.n1848 VGND.n206 2.6561
R3500 VGND.n1855 VGND.n1854 2.6561
R3501 VGND.n232 VGND.n231 2.6561
R3502 VGND.n234 VGND.n233 2.6561
R3503 VGND.n239 VGND.n238 2.6561
R3504 VGND.n1737 VGND.n275 2.62831
R3505 VGND.n1997 VGND.n1995 2.62326
R3506 VGND.n1844 VGND.n181 2.61072
R3507 VGND.n1929 VGND.n108 2.5605
R3508 VGND.n1928 VGND.n112 2.5605
R3509 VGND.n130 VGND.n129 2.5605
R3510 VGND.n134 VGND.n133 2.5605
R3511 VGND.n139 VGND.n126 2.5605
R3512 VGND.n140 VGND.n125 2.5605
R3513 VGND.n145 VGND.n143 2.5605
R3514 VGND.n144 VGND.n122 2.5605
R3515 VGND.n1921 VGND.n1920 2.5605
R3516 VGND.n149 VGND.n123 2.5605
R3517 VGND.n1323 VGND.n1322 2.53355
R3518 VGND.n2003 VGND.n2002 2.52507
R3519 VGND.n1915 VGND.n151 2.47966
R3520 VGND.n864 VGND.n819 2.4726
R3521 VGND.n30 VGND.n29 2.46988
R3522 VGND.n1938 VGND.n101 2.46298
R3523 VGND.n1934 VGND.n1933 2.45173
R3524 VGND.n1733 VGND.n284 2.41639
R3525 VGND.n869 VGND.n819 2.3078
R3526 VGND.n1759 VGND.n262 2.30343
R3527 VGND.n1667 VGND.n463 2.29231
R3528 VGND.n947 VGND.n869 2.28033
R3529 VGND.n1844 VGND.n203 2.23121
R3530 VGND.n1999 VGND.n38 2.21629
R3531 VGND.n1989 VGND.n63 2.14595
R3532 VGND.n1354 VGND.n1351 2.14276
R3533 VGND.n1427 VGND.n1425 2.14276
R3534 VGND.n1426 VGND.n261 2.14276
R3535 VGND.n1760 VGND.n1759 2.14276
R3536 VGND.n259 VGND.n258 2.14276
R3537 VGND.n254 VGND.n248 2.14276
R3538 VGND.n1771 VGND.n255 2.14276
R3539 VGND.n1770 VGND.n256 2.14276
R3540 VGND.n2008 VGND.n2007 2.12846
R3541 VGND.n1849 VGND.n1848 2.12498
R3542 VGND.n1855 VGND.n206 2.12498
R3543 VGND.n233 VGND.n232 2.12498
R3544 VGND.n239 VGND.n234 2.12498
R3545 VGND.n1650 VGND.n555 2.12311
R3546 VGND.n668 VGND.n157 2.12311
R3547 VGND.n1662 VGND.n1661 2.1125
R3548 VGND.n1182 VGND.n1177 2.05178
R3549 VGND.n2010 VGND.n30 2.00546
R3550 VGND.n509 VGND.n470 1.951
R3551 VGND.n1466 VGND.n544 1.951
R3552 VGND.n1937 VGND.n102 1.951
R3553 VGND.n1969 VGND.n75 1.951
R3554 VGND.n1935 VGND.n106 1.951
R3555 VGND.n672 VGND.n671 1.951
R3556 VGND.n1021 VGND.n735 1.951
R3557 VGND.n1998 VGND.n56 1.951
R3558 VGND.n697 VGND.n48 1.951
R3559 VGND.n1971 VGND.n72 1.89141
R3560 VGND.n472 VGND.n89 1.89141
R3561 VGND.n9 VGND.n8 1.8605
R3562 VGND.n238 VGND.n228 1.85942
R3563 VGND.n1946 VGND.n89 1.74595
R3564 VGND.n1972 VGND.n1971 1.74595
R3565 VGND.n2005 VGND.n2004 1.63037
R3566 VGND.n196 VGND.n195 1.55639
R3567 VGND.n7 VGND.n6 1.55639
R3568 VGND.n1854 VGND.n207 1.54075
R3569 VGND.n2003 VGND.n34 1.46209
R3570 VGND.n1273 VGND.n207 1.45707
R3571 VGND.n1791 VGND.n226 1.44364
R3572 VGND.n1997 VGND.n32 1.4194
R3573 VGND.n1733 VGND.n285 1.39918
R3574 VGND.n1778 VGND.n247 1.39297
R3575 VGND.n1781 VGND.n1780 1.32907
R3576 VGND.n2019 VGND.n4 1.32907
R3577 VGND.n1321 VGND.n1320 1.32468
R3578 VGND.n1142 VGND.n1141 1.3077
R3579 VGND.n1031 VGND.n1030 1.30296
R3580 VGND VGND.n2023 1.24857
R3581 VGND.n1634 VGND.n1472 1.24081
R3582 VGND.n1642 VGND.n1641 1.24081
R3583 VGND.n1544 VGND.n1473 1.24081
R3584 VGND.n1545 VGND.n1541 1.24081
R3585 VGND.n1551 VGND.n1550 1.24081
R3586 VGND.n1538 VGND.n1533 1.24081
R3587 VGND.n1561 VGND.n1536 1.24081
R3588 VGND.n1581 VGND.n1493 1.24081
R3589 VGND.n999 VGND.n744 1.21723
R3590 VGND.n1014 VGND.n745 1.21723
R3591 VGND.n1010 VGND.n1009 1.21723
R3592 VGND.n791 VGND.n790 1.21723
R3593 VGND.n795 VGND.n788 1.21723
R3594 VGND.n803 VGND.n778 1.21723
R3595 VGND.n806 VGND.n777 1.21723
R3596 VGND.n814 VGND.n813 1.21723
R3597 VGND.n1635 VGND.n556 1.21689
R3598 VGND.n1671 VGND.n1670 1.20153
R3599 VGND.n438 VGND.n436 1.19453
R3600 VGND.n433 VGND.n321 1.19453
R3601 VGND.n432 VGND.n429 1.19453
R3602 VGND.n426 VGND.n326 1.19453
R3603 VGND.n425 VGND.n422 1.19453
R3604 VGND.n418 VGND.n415 1.19453
R3605 VGND.n412 VGND.n334 1.19453
R3606 VGND.n411 VGND.n408 1.19453
R3607 VGND.n943 VGND.n312 1.19453
R3608 VGND.n1699 VGND.n1698 1.19453
R3609 VGND.n1704 VGND.n1703 1.19453
R3610 VGND.n445 VGND.n444 1.19453
R3611 VGND.n1689 VGND.n446 1.19453
R3612 VGND.n1681 VGND.n452 1.19453
R3613 VGND.n459 VGND.n455 1.19453
R3614 VGND.n1675 VGND.n460 1.19453
R3615 VGND.n665 VGND.n664 1.1912
R3616 VGND.n1313 VGND.n1312 1.1912
R3617 VGND.n689 VGND.n688 1.1912
R3618 VGND.n1282 VGND.n684 1.1912
R3619 VGND.n1290 VGND.n683 1.1912
R3620 VGND.n1293 VGND.n680 1.1912
R3621 VGND.n1297 VGND.n1296 1.1912
R3622 VGND.n1738 VGND.n1737 1.18726
R3623 VGND.n1306 VGND.n663 1.163
R3624 VGND.n320 VGND.n101 1.15277
R3625 VGND.n63 VGND.n59 1.12777
R3626 VGND.n727 VGND.n726 1.11989
R3627 VGND.n1161 VGND.n1160 1.11989
R3628 VGND.n1062 VGND.n1061 1.11989
R3629 VGND.n1069 VGND.n1067 1.11989
R3630 VGND.n1074 VGND.n1057 1.11989
R3631 VGND.n1084 VGND.n1082 1.11989
R3632 VGND.n1087 VGND.n1056 1.11989
R3633 VGND.n1146 VGND.n1088 1.11989
R3634 VGND.n1272 VGND.n1175 1.10777
R3635 VGND.n1275 VGND.n1274 1.09548
R3636 VGND.n309 VGND.n33 1.07944
R3637 VGND VGND.n780 1.07122
R3638 VGND.n1791 VGND.n1790 1.06274
R3639 VGND.n1635 VGND.n1634 1.04236
R3640 VGND.n1306 VGND.n1305 1.04236
R3641 VGND.n1154 VGND.n1153 1.02255
R3642 VGND.n438 VGND.n320 1.00349
R3643 VGND VGND.n1685 1.00349
R3644 VGND.n1642 VGND.n1472 0.992748
R3645 VGND.n1641 VGND.n1473 0.992748
R3646 VGND.n1545 VGND.n1544 0.992748
R3647 VGND.n1550 VGND.n1541 0.992748
R3648 VGND.n1555 VGND.n1551 0.992748
R3649 VGND VGND.n1554 0.992748
R3650 VGND.n1554 VGND.n1538 0.992748
R3651 VGND.n1561 VGND.n1533 0.992748
R3652 VGND.n1536 VGND.n1493 0.992748
R3653 VGND.n1581 VGND.n1580 0.992748
R3654 VGND.n664 VGND.n593 0.992748
R3655 VGND.n1312 VGND.n594 0.992748
R3656 VGND.n692 VGND.n689 0.992748
R3657 VGND.n1278 VGND.n1277 0.992748
R3658 VGND.n1282 VGND.n1281 0.992748
R3659 VGND.n1286 VGND.n1285 0.992748
R3660 VGND.n1290 VGND.n1289 0.992748
R3661 VGND.n1298 VGND.n1293 0.992748
R3662 VGND.n1296 VGND.n585 0.992748
R3663 VGND.n726 VGND.n704 0.973884
R3664 VGND.n1160 VGND.n705 0.973884
R3665 VGND.n1065 VGND.n1062 0.973884
R3666 VGND.n1070 VGND.n1069 0.973884
R3667 VGND.n1074 VGND.n1073 0.973884
R3668 VGND.n1079 VGND.n1077 0.973884
R3669 VGND.n1084 VGND.n1083 0.973884
R3670 VGND.n1147 VGND.n1087 0.973884
R3671 VGND.n1089 VGND.n1088 0.973884
R3672 VGND.n436 VGND.n321 0.955724
R3673 VGND.n433 VGND.n432 0.955724
R3674 VGND.n429 VGND.n326 0.955724
R3675 VGND.n426 VGND.n425 0.955724
R3676 VGND.n422 VGND.n330 0.955724
R3677 VGND.n419 VGND 0.955724
R3678 VGND.n419 VGND.n418 0.955724
R3679 VGND.n415 VGND.n334 0.955724
R3680 VGND.n412 VGND.n411 0.955724
R3681 VGND.n408 VGND.n339 0.955724
R3682 VGND.n945 VGND.n944 0.955724
R3683 VGND.n1580 VGND.n276 0.943136
R3684 VGND.n1285 VGND 0.943136
R3685 VGND.n1887 VGND.n1886 0.933163
R3686 VGND.n1885 VGND.n182 0.931409
R3687 VGND.n1653 VGND.n1651 0.9285
R3688 VGND.n154 VGND.n153 0.9285
R3689 VGND.n1001 VGND.n1000 0.925215
R3690 VGND.n948 VGND.n775 0.925215
R3691 VGND.n339 VGND.n281 0.907963
R3692 VGND.n1697 VGND.n312 0.907963
R3693 VGND.n1699 VGND.n308 0.907963
R3694 VGND.n1690 VGND.n445 0.907963
R3695 VGND.n447 VGND.n446 0.907963
R3696 VGND.n1685 VGND.n448 0.907963
R3697 VGND.n1681 VGND.n1680 0.907963
R3698 VGND.n1676 VGND.n459 0.907963
R3699 VGND.n461 VGND.n460 0.907963
R3700 VGND.n1672 VGND.n1671 0.907963
R3701 VGND.n1736 VGND.n276 0.893523
R3702 VGND.n1320 VGND.n1319 0.893523
R3703 VGND.n1001 VGND.n736 0.876546
R3704 VGND.n1015 VGND.n744 0.876546
R3705 VGND.n756 VGND.n745 0.876546
R3706 VGND.n1009 VGND.n757 0.876546
R3707 VGND.n794 VGND.n791 0.876546
R3708 VGND.n799 VGND.n788 0.876546
R3709 VGND.n802 VGND.n780 0.876546
R3710 VGND.n807 VGND.n778 0.876546
R3711 VGND.n810 VGND.n777 0.876546
R3712 VGND.n813 VGND.n812 0.876546
R3713 VGND.n948 VGND.n947 0.876546
R3714 VGND.n1154 VGND.n696 0.876546
R3715 VGND.n1077 VGND 0.876546
R3716 VGND.n1734 VGND.n281 0.860201
R3717 VGND.n946 VGND.n945 0.860201
R3718 VGND.n1443 VGND.n226 0.857404
R3719 VGND.n1168 VGND.n1167 0.844053
R3720 VGND.n1022 VGND.n1020 0.834494
R3721 VGND.n1143 VGND.n1142 0.827876
R3722 VGND.n20 VGND.n19 0.816075
R3723 VGND.n24 VGND.n23 0.816075
R3724 VGND.n25 VGND.n24 0.816075
R3725 VGND.n25 VGND.n14 0.816075
R3726 VGND.n29 VGND.n14 0.816075
R3727 VGND.n1503 VGND.n283 0.804872
R3728 VGND.n1574 VGND.n278 0.804872
R3729 VGND.n1735 VGND.n280 0.763414
R3730 VGND.n1778 VGND.n1777 0.750291
R3731 VGND.n1256 VGND.n1255 0.729404
R3732 VGND.n23 VGND.n16 0.725456
R3733 VGND.n7 VGND 0.72153
R3734 VGND.n1866 VGND.n198 0.715885
R3735 VGND.n1703 VGND.n309 0.693037
R3736 VGND.n1275 VGND.n694 0.620655
R3737 VGND.n1879 VGND.n182 0.60792
R3738 VGND VGND.n198 0.6005
R3739 VGND.n231 VGND.n207 0.584732
R3740 VGND.n1277 VGND.n1275 0.571043
R3741 VGND.n196 VGND 0.567
R3742 VGND.n2013 VGND.n2012 0.564732
R3743 VGND.n1780 VGND 0.545228
R3744 VGND.n2004 VGND.n2003 0.517167
R3745 VGND.n2022 VGND 0.502941
R3746 VGND.n43 VGND.n32 0.487697
R3747 VGND.n695 VGND.n33 0.434711
R3748 VGND.n1274 VGND.n1273 0.418921
R3749 VGND.n1259 VGND.n1257 0.399116
R3750 VGND.n1274 VGND.n695 0.382079
R3751 VGND.n1750 VGND.n1749 0.381957
R3752 VGND.n262 VGND.n259 0.375395
R3753 VGND.n1955 VGND 0.364136
R3754 VGND.n495 VGND 0.364136
R3755 VGND.n1981 VGND 0.364136
R3756 VGND.n872 VGND.n107 0.357582
R3757 VGND.n1255 VGND.n182 0.320776
R3758 VGND.n1933 VGND.n108 0.3205
R3759 VGND.n1929 VGND.n1928 0.3205
R3760 VGND.n129 VGND.n112 0.3205
R3761 VGND.n133 VGND.n130 0.3205
R3762 VGND.n134 VGND.n126 0.3205
R3763 VGND.n140 VGND.n139 0.3205
R3764 VGND.n143 VGND.n125 0.3205
R3765 VGND.n145 VGND.n144 0.3205
R3766 VGND.n1921 VGND.n122 0.3205
R3767 VGND.n1920 VGND.n123 0.3205
R3768 VGND.n153 VGND.n149 0.3205
R3769 VGND.n1447 VGND.n1348 0.289947
R3770 VGND.n2005 VGND.n5 0.283833
R3771 VGND.n1934 VGND.n107 0.275178
R3772 VGND.n1790 VGND.n228 0.26606
R3773 VGND.n1555 VGND 0.248562
R3774 VGND.n687 VGND 0.248562
R3775 VGND.n1273 VGND.n1272 0.245237
R3776 VGND.n1060 VGND 0.243846
R3777 VGND VGND.n330 0.239306
R3778 VGND.n1031 VGND.n695 0.233
R3779 VGND.n442 VGND.n309 0.215425
R3780 VGND.n1686 VGND 0.191545
R3781 VGND.n197 VGND 0.186214
R3782 VGND.n1257 VGND.n1256 0.16616
R3783 VGND.n798 VGND 0.146508
R3784 VGND.n2011 VGND.n2009 0.138453
R3785 VGND.n947 VGND.n946 0.137839
R3786 VGND.n2004 VGND.n33 0.129447
R3787 VGND.n2021 VGND.n4 0.118242
R3788 VGND.n1780 VGND 0.111913
R3789 VGND.n1141 VGND.n151 0.108289
R3790 VGND.n1915 VGND.n1914 0.108289
R3791 VGND.n1000 VGND.n999 0.0978384
R3792 VGND.n1015 VGND.n1014 0.0978384
R3793 VGND.n1010 VGND.n756 0.0978384
R3794 VGND.n790 VGND.n757 0.0978384
R3795 VGND.n795 VGND.n794 0.0978384
R3796 VGND.n799 VGND.n798 0.0978384
R3797 VGND.n803 VGND.n802 0.0978384
R3798 VGND.n807 VGND.n806 0.0978384
R3799 VGND.n814 VGND.n810 0.0978384
R3800 VGND.n812 VGND.n775 0.0978384
R3801 VGND.n1153 VGND.n727 0.0978384
R3802 VGND.n1161 VGND.n704 0.0978384
R3803 VGND.n1061 VGND.n705 0.0978384
R3804 VGND.n1067 VGND.n1065 0.0978384
R3805 VGND.n1070 VGND.n1057 0.0978384
R3806 VGND.n1073 VGND.n1060 0.0978384
R3807 VGND.n1082 VGND.n1079 0.0978384
R3808 VGND.n1083 VGND.n1056 0.0978384
R3809 VGND.n1147 VGND.n1146 0.0978384
R3810 VGND.n1143 VGND.n1089 0.0978384
R3811 VGND VGND.n4 0.0952581
R3812 VGND.n20 VGND.n16 0.0911195
R3813 VGND.n21 VGND.n17 0.0905
R3814 VGND.n22 VGND.n21 0.0905
R3815 VGND.n22 VGND.n15 0.0905
R3816 VGND.n26 VGND.n15 0.0905
R3817 VGND.n27 VGND.n26 0.0905
R3818 VGND.n8 VGND 0.0814352
R3819 VGND.n668 VGND.n154 0.0813421
R3820 VGND.n2010 VGND.n2008 0.0684646
R3821 VGND.n1322 VGND.n1321 0.0543947
R3822 VGND.n1323 VGND.n554 0.0543947
R3823 VGND.n673 VGND.n669 0.0543947
R3824 VGND.n674 VGND.n663 0.0543947
R3825 VGND.n197 VGND.n196 0.054
R3826 VGND.n197 VGND 0.0525
R3827 VGND.n1305 VGND.n665 0.0501124
R3828 VGND.n1313 VGND.n593 0.0501124
R3829 VGND.n688 VGND.n594 0.0501124
R3830 VGND.n694 VGND.n692 0.0501124
R3831 VGND.n1278 VGND.n684 0.0501124
R3832 VGND.n1281 VGND.n687 0.0501124
R3833 VGND.n1286 VGND.n683 0.0501124
R3834 VGND.n1289 VGND.n680 0.0501124
R3835 VGND.n1298 VGND.n1297 0.0501124
R3836 VGND.n1319 VGND.n585 0.0501124
R3837 VGND.n1670 VGND.n1667 0.0492619
R3838 VGND.n1663 VGND.n463 0.0492619
R3839 VGND.n944 VGND.n943 0.0482612
R3840 VGND.n1698 VGND.n1697 0.0482612
R3841 VGND.n1704 VGND.n308 0.0482612
R3842 VGND.n444 VGND.n442 0.0482612
R3843 VGND.n1690 VGND.n1689 0.0482612
R3844 VGND.n1686 VGND.n447 0.0482612
R3845 VGND.n452 VGND.n448 0.0482612
R3846 VGND.n1680 VGND.n455 0.0482612
R3847 VGND.n1676 VGND.n1675 0.0482612
R3848 VGND.n1672 VGND.n461 0.0482612
R3849 VGND.n2023 VGND.n5 0.03175
R3850 VGND.n1651 VGND.n1650 0.0274474
R3851 VGND.n1662 VGND.n100 0.024881
R3852 VGND.n2009 VGND 0.0232273
R3853 VGND.n8 VGND.n7 0.0144388
R3854 VGND.n28 VGND.n27 0.01425
R3855 VGND.n2023 VGND.n2022 0.00908779
C0 VDPWR MSU1.S 0.85466f
C1 RCTAT_lay_0.A Q1.Emitter 0.36175f
C2 ui_in[0] RL_lay_0.R4.R2 0.23244f
C3 M1.S1 VDPWR 2.5638f
C4 ui_in[0] ME1.S 0.85796f
C5 M1.G0 MSU1.S 0.17513f
C6 RCTAT_lay_0.sky130_fd_pr__res_xhigh_po_0p35_7LQ4N7_5.R2 RCTAT_lay_0.sky130_fd_pr__res_xhigh_po_0p35_7LQ4N7_3.R2 0.26016f
C7 VDPWR ua[0] 2.55702f
C8 RCTAT_lay_0.A RCTAT_lay_0.sky130_fd_pr__res_xhigh_po_0p35_7LQ4N7_2.R1 0.38207f
C9 M1.S1 M1.G0 8.99414f
C10 ui_in[0] inv_0.Y 0.49386f
C11 MSU1.S ME1.S 0.43673f
C12 M1.G0 ua[0] 4.40811f
C13 RL_lay_0.R4.R2 RL_lay_0.sky130_fd_pr__res_xhigh_po_0p35_RTNBCE_0.R2 0.26016f
C14 RCTAT_lay_0.A RPTAT_lay_0.B 0.84286f
C15 RCTAT_lay_0.A M1.S1 4.21255f
C16 RCTAT_lay_0.A RCTAT_lay_0.sky130_fd_pr__res_xhigh_po_0p35_7LQ4N7_4.R1 0.10862f
C17 ua[0] RL_lay_0.R3.R1 0.39297f
C18 ui_in[0] MSU1.S 0.10572f
C19 Q1.Emitter RPTAT_lay_0.B 1.72159f
C20 Q1.Emitter M1.S1 5.38192f
C21 M1.G0 VDPWR 31.7443f
C22 M1.S1 inv_0.Y 0.1038f
C23 M1.S1 ui_in[0] 1.08519f
C24 VDPWR ME1.S 1.8469f
C25 ui_in[0] RL_lay_0.sky130_fd_pr__res_xhigh_po_0p35_RTNBCE_0.R2 0.18207f
C26 RCTAT_lay_0.sky130_fd_pr__res_xhigh_po_0p35_7LQ4N7_4.R1 RCTAT_lay_0.sky130_fd_pr__res_xhigh_po_0p35_7LQ4N7_2.R1 0.26035f
C27 ua[0] ui_in[0] 0.11924f
C28 M1.S1 ME2.S 0.11748f
C29 M1.S1 MSU1.S 0.28923f
C30 VDPWR inv_0.Y 0.61381f
C31 M1.G0 ME1.S 0.48031f
C32 RCTAT_lay_0.A M1.G0 2.23607f
C33 VDPWR ui_in[0] 1.77991f
C34 M1.S1 RPTAT_lay_0.B 0.20207f
C35 RCTAT_lay_0.sky130_fd_pr__res_xhigh_po_0p35_7LQ4N7_1.R2 RCTAT_lay_0.sky130_fd_pr__res_xhigh_po_0p35_7LQ4N7_3.R2 0.26025f
C36 M1.G0 ui_in[0] 0.26723f
C37 ui_in[0] VGND 5.56929f
C38 ua[0] VGND 2.76503f
C39 VDPWR VGND 63.40648f
C40 RCTAT_lay_0.sky130_fd_pr__res_xhigh_po_0p35_7LQ4N7_5.R2 VGND 0.78807f
C41 RCTAT_lay_0.sky130_fd_pr__res_xhigh_po_0p35_7LQ4N7_4.R1 VGND 0.76531f
C42 RCTAT_lay_0.sky130_fd_pr__res_xhigh_po_0p35_7LQ4N7_3.R2 VGND 0.51652f
C43 RCTAT_lay_0.sky130_fd_pr__res_xhigh_po_0p35_7LQ4N7_2.R1 VGND 0.5097f
C44 RCTAT_lay_0.sky130_fd_pr__res_xhigh_po_0p35_7LQ4N7_1.R2 VGND 0.72741f
C45 RL_lay_0.R4.R2 VGND 0.71955f
C46 RL_lay_0.R3.R1 VGND 0.70564f
C47 RL_lay_0.sky130_fd_pr__res_xhigh_po_0p35_RTNBCE_0.R2 VGND 0.70872f
C48 RPTAT_lay_0.B VGND 14.8833f
C49 ME2.S VGND 0.26674f
C50 MSU1.S VGND 0.27544f
C51 ME1.S VGND 0.40084f
C52 inv_0.Y VGND 0.89611f
C53 RCTAT_lay_0.A VGND 9.43577f
C54 Q1.Emitter VGND 5.43069f
C55 M1.S1 VGND 17.6002f
C56 M1.G0 VGND 3.64753f
C57 VDPWR.n99 VGND 0.1883f
C58 VDPWR.n100 VGND 0.61561f
C59 VDPWR.n101 VGND 0.47183f
C60 VDPWR.n102 VGND 0.4039f
C61 VDPWR.n103 VGND 0.28765f
C62 VDPWR.n104 VGND 0.35478f
C63 VDPWR.n105 VGND 3.74351f
C64 VDPWR.n106 VGND 1.87019f
C65 VDPWR.n107 VGND 0.63054f
C66 VDPWR.t34 VGND 1.2544f
C67 VDPWR.t32 VGND 0.95841f
C68 VDPWR.t37 VGND 0.75317f
C69 VDPWR.t30 VGND 0.78637f
C70 VDPWR.t36 VGND 0.75317f
C71 VDPWR.t28 VGND 0.44297f
C72 VDPWR.n108 VGND 0.29074f
C73 VDPWR.t43 VGND 0.71883f
C74 VDPWR.t26 VGND 0.54153f
C75 VDPWR.t41 VGND 0.59877f
C76 VDPWR.t39 VGND 0.62955f
C77 VDPWR.t24 VGND -0.10018f
C78 VDPWR.n110 VGND 0.20494f
C79 VDPWR.n112 VGND 0.23356f
C80 VDPWR.n129 VGND 0.28066f
C81 VDPWR.n143 VGND 0.16835f
C82 VDPWR.n145 VGND 0.28431f
C83 VDPWR.n146 VGND 0.88231f
C84 VDPWR.t22 VGND 1.12283f
C85 VDPWR.t20 VGND 1.03292f
C86 VDPWR.t18 VGND 0.77312f
C87 VDPWR.t0 VGND 1.29508f
C88 VDPWR.t2 VGND 1.03292f
C89 VDPWR.t4 VGND 1.03292f
C90 VDPWR.t6 VGND 1.03292f
C91 VDPWR.t8 VGND 1.03292f
C92 VDPWR.t10 VGND 1.23856f
C93 VDPWR.t12 VGND 1.23856f
C94 VDPWR.t14 VGND 1.03292f
C95 VDPWR.t16 VGND 0.77626f
C96 VDPWR.n147 VGND 0.51646f
C97 VDPWR.n148 VGND 0.81132f
C98 VDPWR.n149 VGND 2.83629f
C99 VDPWR.n150 VGND 0.1136f
C100 VDPWR.n151 VGND 0.3565f
C101 VDPWR.n152 VGND 0.4014f
C102 VDPWR.n153 VGND 0.28937f
C103 VDPWR.n154 VGND 0.47183f
C104 VDPWR.n155 VGND 0.88416f
C105 ua[0].n7 VGND 0.12449f
C106 ua[0].n10 VGND 0.17323f
C107 ua[0].n11 VGND 0.17961f
C108 ua[0].n12 VGND 0.2733f
C109 ua[0].n13 VGND 0.13106f
C110 ua[0].n17 VGND 0.39701f
C111 ua[0].n27 VGND 0.13038f
C112 ua[0].n32 VGND 0.39018f
C113 ua[0].n33 VGND 0.52549f
C114 ua[0].n34 VGND 0.38202f
C115 ua[0].n46 VGND 0.1445f
C116 ua[0].n51 VGND 0.13021f
C117 ua[0].n53 VGND 0.12307f
C118 ua[0].n54 VGND 0.22605f
C119 ua[0].n55 VGND 1.16604f
C120 ua[0].n56 VGND 0.19418f
C121 ua[0].n57 VGND 0.24057f
C122 ui_in[0].n2 VGND 0.45136f
C123 ui_in[0].t4 VGND 0.19472f
C124 ui_in[0].n3 VGND 0.15257f
C125 ui_in[0].n4 VGND 1.34482f
C126 ui_in[0].n5 VGND 0.12201f
C127 ui_in[0].t3 VGND 0.27329f
C128 ui_in[0].n8 VGND 0.19278f
C129 ui_in[0].t2 VGND 0.27329f
.ends
