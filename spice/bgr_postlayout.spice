* NGSPICE file created from BGR_lay.ext - technology: sky130A

.subckt BGR_lay VIN VSS VREF EN
X0 VSS.t25 VSS.t27 RPTAT_lay_0.B sky130_fd_pr__pnp_05v5_W3p40L3p40
**devattr s=462400,2720 d=46053255,55725
X1 VSS.t29 VSS.t32 RPTAT_lay_0.B sky130_fd_pr__pnp_05v5_W3p40L3p40
**devattr s=462400,2720 d=46053255,55725
X2 VREF.t5 M1.G0 VIN.t28 VIN.t27 sky130_fd_pr__pfet_01v8_lvt ad=0.725 pd=5.29 as=1.45 ps=10.58 w=5 l=3
X3 M1.G0 ME1.S ME2.S VSS.t9 sky130_fd_pr__nfet_01v8 ad=0.145 pd=1.58 as=0.145 ps=1.58 w=0.5 l=0.15
X4 VSS.t40 RCTAT_lay_0.R6.R1 VSS.t39 sky130_fd_pr__res_xhigh_po_0p35 l=4.08
X5 VSS.t29 VSS.t28 RPTAT_lay_0.B sky130_fd_pr__pnp_05v5_W3p40L3p40
**devattr s=462400,2720 d=46053255,55725
X6 VSS.t34 VSS.t36 Q1.Emitter sky130_fd_pr__pnp_05v5_W3p40L3p40
**devattr s=462400,2720 d=46053255,55725
X7 VIN.t22 M1.G0 M1.G0 VIN.t21 sky130_fd_pr__pfet_01v8_lvt ad=0.725 pd=5.29 as=0.725 ps=5.29 w=5 l=3
X8 VREF.t1 M1.G0 VIN.t36 VIN.t35 sky130_fd_pr__pfet_01v8_lvt ad=0.725 pd=5.29 as=0.725 ps=5.29 w=5 l=3
X9 inv_0.Y EN.t1 VSS.t20 VSS.t19 sky130_fd_pr__nfet_01v8 ad=0.145 pd=1.58 as=0.145 ps=1.58 w=0.5 l=0.5
X10 RL_lay_0.R3.R1 RL_lay_0.R4.R2 VSS.t17 sky130_fd_pr__res_xhigh_po_0p35 l=4.18
X11 VSS.t31 VSS.t30 RPTAT_lay_0.B sky130_fd_pr__pnp_05v5_W3p40L3p40
**devattr s=462400,2720 d=46053255,55725
X12 Q1.Emitter M1.S1 M1.S1 VSS.t5 sky130_fd_pr__nfet_01v8_lvt ad=1.45 pd=10.58 as=0.725 ps=5.29 w=5 l=3
X13 M1.G0 M1.G0 VIN.t16 VIN.t15 sky130_fd_pr__pfet_01v8_lvt ad=0.725 pd=5.29 as=1.45 ps=10.58 w=5 l=3
X14 RL_lay_0.R3.R1 RL_lay_0.R2.R2 VSS.t16 sky130_fd_pr__res_xhigh_po_0p35 l=4.18
X15 RCTAT_lay_0.R5.R1 RCTAT_lay_0.R4.R2 VSS.t18 sky130_fd_pr__res_xhigh_po_0p35 l=4.08
X16 VIN.t10 M1.G0 M1.S1 VIN.t9 sky130_fd_pr__pfet_01v8_lvt ad=0.725 pd=5.29 as=0.725 ps=5.29 w=5 l=3
X17 M1.S1 M1.G0 VIN.t12 VIN.t11 sky130_fd_pr__pfet_01v8_lvt ad=0.725 pd=5.29 as=0.725 ps=5.29 w=5 l=3
X18 RCTAT_lay_0.A M1.S1 M1.G0 VSS.t6 sky130_fd_pr__nfet_01v8_lvt ad=0.725 pd=5.29 as=0.725 ps=5.29 w=5 l=3
X19 VSS.t15 RL_lay_0.R4.R2 VSS.t14 sky130_fd_pr__res_xhigh_po_0p35 l=4.18
X20 ME2.S EN.t0 M1.S1 VSS.t21 sky130_fd_pr__nfet_01v8 ad=0.29 pd=2.58 as=0.29 ps=2.58 w=1 l=0.3
X21 VSS.t34 VSS.t33 RPTAT_lay_0.B sky130_fd_pr__pnp_05v5_W3p40L3p40
**devattr s=462400,2720 d=46053255,55725
X22 ME1.S ME1.S VIN.t2 VIN.t1 sky130_fd_pr__pfet_01v8 ad=0.29 pd=2.58 as=0.29 ps=2.58 w=1 l=2
X23 VSS.t34 VSS.t35 RPTAT_lay_0.B sky130_fd_pr__pnp_05v5_W3p40L3p40
**devattr s=462400,2720 d=46053255,55725
X24 RCTAT_lay_0.A RPTAT_lay_0.B VSS.t13 sky130_fd_pr__res_xhigh_po_0p35 l=3.2
X25 VSS.t25 VSS.t26 RPTAT_lay_0.B sky130_fd_pr__pnp_05v5_W3p40L3p40
**devattr s=462400,2720 d=46053255,55725
X26 RCTAT_lay_0.R3.R1 RCTAT_lay_0.R2.R2 VSS.t22 sky130_fd_pr__res_xhigh_po_0p35 l=4.08
X27 VIN.t30 M1.G0 VREF.t4 VIN.t29 sky130_fd_pr__pfet_01v8_lvt ad=0.725 pd=5.29 as=0.725 ps=5.29 w=5 l=3
X28 M1.G0 M1.G0 VIN.t24 VIN.t23 sky130_fd_pr__pfet_01v8_lvt ad=0.725 pd=5.29 as=0.725 ps=5.29 w=5 l=3
X29 VIN.t38 M1.G0 VREF.t6 VIN.t37 sky130_fd_pr__pfet_01v8_lvt ad=1.45 pd=10.58 as=0.725 ps=5.29 w=5 l=3
X30 M1.G0 M1.G0 VIN.t20 VIN.t19 sky130_fd_pr__pfet_01v8_lvt ad=0.725 pd=5.29 as=0.725 ps=5.29 w=5 l=3
X31 VREF.t2 M1.G0 VIN.t32 VIN.t31 sky130_fd_pr__pfet_01v8_lvt ad=0.725 pd=5.29 as=0.725 ps=5.29 w=5 l=3
X32 Q1.Emitter M1.S1 M1.S1 VSS.t3 sky130_fd_pr__nfet_01v8_lvt ad=0.725 pd=5.29 as=0.725 ps=5.29 w=5 l=3
X33 M1.S1 M1.S1 Q1.Emitter VSS.t4 sky130_fd_pr__nfet_01v8_lvt ad=0.725 pd=5.29 as=0.725 ps=5.29 w=5 l=3
X34 MSU1.S M1.S1 VSS.t8 VSS.t7 sky130_fd_pr__nfet_01v8 ad=0.29 pd=2.58 as=0.29 ps=2.58 w=1 l=2
X35 M1.S1 M1.G0 VIN.t4 VIN.t3 sky130_fd_pr__pfet_01v8_lvt ad=0.725 pd=5.29 as=1.45 ps=10.58 w=5 l=3
X36 VIN.t6 M1.G0 M1.S1 VIN.t5 sky130_fd_pr__pfet_01v8_lvt ad=0.725 pd=5.29 as=0.725 ps=5.29 w=5 l=3
X37 M1.G0 M1.S1 RCTAT_lay_0.A VSS.t6 sky130_fd_pr__nfet_01v8_lvt ad=0.725 pd=5.29 as=1.45 ps=10.58 w=5 l=3
X38 M1.G0 M1.S1 RCTAT_lay_0.A VSS.t6 sky130_fd_pr__nfet_01v8_lvt ad=0.725 pd=5.29 as=0.725 ps=5.29 w=5 l=3
X39 RCTAT_lay_0.A RCTAT_lay_0.R2.R2 VSS.t37 sky130_fd_pr__res_xhigh_po_0p35 l=4.08
X40 M1.S1 M1.G0 VIN.t8 VIN.t7 sky130_fd_pr__pfet_01v8_lvt ad=0.725 pd=5.29 as=0.725 ps=5.29 w=5 l=3
X41 RCTAT_lay_0.R5.R1 RCTAT_lay_0.R6.R1 VSS.t38 sky130_fd_pr__res_xhigh_po_0p35 l=4.08
X42 VIN.t26 M1.G0 M1.G0 VIN.t25 sky130_fd_pr__pfet_01v8_lvt ad=1.45 pd=10.58 as=0.725 ps=5.29 w=5 l=3
X43 VREF.t0 RL_lay_0.R2.R2 VSS.t12 sky130_fd_pr__res_xhigh_po_0p35 l=4.18
X44 VIN.t18 M1.G0 M1.G0 VIN.t17 sky130_fd_pr__pfet_01v8_lvt ad=0.725 pd=5.29 as=0.725 ps=5.29 w=5 l=3
X45 VIN.t34 M1.G0 VREF.t3 VIN.t33 sky130_fd_pr__pfet_01v8_lvt ad=0.725 pd=5.29 as=0.725 ps=5.29 w=5 l=3
X46 M1.S1 inv_0.Y VSS.t11 VSS.t10 sky130_fd_pr__nfet_01v8 ad=0.145 pd=1.58 as=0.145 ps=1.58 w=0.5 l=0.5
X47 M1.S1 M1.S1 Q1.Emitter VSS.t0 sky130_fd_pr__nfet_01v8_lvt ad=0.725 pd=5.29 as=1.45 ps=10.58 w=5 l=3
X48 RCTAT_lay_0.R3.R1 RCTAT_lay_0.R4.R2 VSS.t23 sky130_fd_pr__res_xhigh_po_0p35 l=4.08
X49 VIN.t14 M1.G0 M1.S1 VIN.t13 sky130_fd_pr__pfet_01v8_lvt ad=1.45 pd=10.58 as=0.725 ps=5.29 w=5 l=3
X50 Q1.Emitter M1.S1 M1.S1 VSS.t1 sky130_fd_pr__nfet_01v8_lvt ad=0.725 pd=5.29 as=0.725 ps=5.29 w=5 l=3
X51 VSS.t25 VSS.t24 RPTAT_lay_0.B sky130_fd_pr__pnp_05v5_W3p40L3p40
**devattr s=462400,2720 d=46053255,55725
X52 RCTAT_lay_0.A M1.S1 M1.G0 VSS.t6 sky130_fd_pr__nfet_01v8_lvt ad=1.45 pd=10.58 as=0.725 ps=5.29 w=5 l=3
X53 inv_0.Y EN.t4 VIN.t40 VIN.t39 sky130_fd_pr__pfet_01v8 ad=0.58 pd=4.58 as=0.58 ps=4.58 w=2 l=0.5
X54 M1.S1 M1.S1 Q1.Emitter VSS.t2 sky130_fd_pr__nfet_01v8_lvt ad=0.725 pd=5.29 as=0.725 ps=5.29 w=5 l=3
X55 RCTAT_lay_0.A M1.S1 M1.G0 VSS.t6 sky130_fd_pr__nfet_01v8_lvt ad=0.725 pd=5.29 as=0.725 ps=5.29 w=5 l=3
X56 M1.G0 M1.S1 RCTAT_lay_0.A VSS.t6 sky130_fd_pr__nfet_01v8_lvt ad=0.725 pd=5.29 as=0.725 ps=5.29 w=5 l=3
X57 ME1.S EN.t3 VIN.t42 VIN.t41 sky130_fd_pr__pfet_01v8 ad=0.348 pd=2.98 as=0.348 ps=2.98 w=1.2 l=1
X58 M1.G0 EN.t2 VIN.t44 VIN.t43 sky130_fd_pr__pfet_01v8 ad=0.348 pd=2.98 as=0.348 ps=2.98 w=1.2 l=1
X59 MSU1.S MSU1.S ME1.S VIN.t0 sky130_fd_pr__pfet_01v8 ad=0.29 pd=2.58 as=0.29 ps=2.58 w=1 l=2
R0 EN EN.t0 274.108
R1 EN EN.t4 248.4
R2 EN EN.t3 180.921
R3 EN EN.t2 180.921
R4 EN EN.t1 176.101
R5 EN.n2 EN 12.7231
R6 EN.n0 EN 9.5505
R7 EN.n0 EN 9.47907
R8 EN EN.n3 8.19824
R9 EN.n1 EN 6.86925
R10 EN.n2 EN 4.65505
R11 EN.n1 EN 4.55362
R12 EN.n3 EN.n1 2.64609
R13 EN.n3 EN.n2 1.5005
R14 EN EN.n0 0.383312
R15 VREF VREF.n4 83.5719
R16 VREF VREF.n6 83.5719
R17 VREF VREF.n0 83.5719
R18 VREF.n1 VREF.t0 40.8142
R19 VREF.n1 VREF 33.275
R20 VREF.n4 VREF.t6 5.7135
R21 VREF.n4 VREF.t1 5.7135
R22 VREF.n6 VREF.t4 5.7135
R23 VREF.n6 VREF.t5 5.7135
R24 VREF.n0 VREF.t3 5.7135
R25 VREF.n0 VREF.t2 5.7135
R26 VREF.n7 VREF 2.39455
R27 VREF VREF.n1 1.67389
R28 VREF.n7 VREF.n5 1.3274
R29 VREF VREF.n7 1.07012
R30 VREF.n5 VREF 1.02618
R31 VREF.n3 VREF.n2 0.949859
R32 VREF.n5 VREF.n3 0.549129
R33 VREF.n3 VREF 0.38077
R34 VREF.n2 VREF 0.0255
R35 VREF.n2 VREF 0.00883333
R36 VIN.n22 VIN 29798.8
R37 VIN.n28 VIN.n21 3810.59
R38 VIN.n14 VIN.n12 3068.63
R39 VIN.n24 VIN.n21 2505.88
R40 VIN.n24 VIN.n23 2470.59
R41 VIN.n28 VIN 1789.41
R42 VIN.n23 VIN 1694.12
R43 VIN VIN.n26 1310.21
R44 VIN.n23 VIN.n22 1129.69
R45 VIN.n22 VIN 1047.7
R46 VIN.n31 VIN.n8 1034.5
R47 VIN.n25 VIN.n24 1004
R48 VIN.n26 VIN 973.47
R49 VIN.n25 VIN 797.648
R50 VIN VIN.n25 797.648
R51 VIN.t15 VIN.t13 638.889
R52 VIN VIN.t2 613.566
R53 VIN VIN.t44 608.804
R54 VIN VIN.t42 608.804
R55 VIN.n27 VIN.t25 515.487
R56 VIN.n14 VIN.n8 496.325
R57 VIN.n26 VIN.n21 470.937
R58 VIN.t25 VIN.t23 456.945
R59 VIN.t23 VIN.t21 456.945
R60 VIN.t21 VIN.t19 456.945
R61 VIN.t19 VIN.t17 456.945
R62 VIN.t17 VIN.t15 456.945
R63 VIN.t13 VIN.t11 456.945
R64 VIN.t11 VIN.t9 456.945
R65 VIN.t9 VIN.t7 456.945
R66 VIN.t7 VIN.t5 456.945
R67 VIN.t5 VIN.t3 456.945
R68 VIN.t35 VIN.t37 405.45
R69 VIN.n29 VIN.n20 319.815
R70 VIN.n31 VIN.n30 280.774
R71 VIN.n19 VIN.n12 259.389
R72 VIN.t39 VIN.t41 217.619
R73 VIN VIN.t40 209.284
R74 VIN.t29 VIN.t43 192.381
R75 VIN.t33 VIN.t1 183.81
R76 VIN.n20 VIN.n19 170.166
R77 VIN.t31 VIN.t0 170
R78 VIN.t0 VIN.t33 143.333
R79 VIN.t1 VIN.t35 129.524
R80 VIN.t43 VIN.t31 120.953
R81 VIN.n30 VIN.n29 117.46
R82 VIN.n20 VIN.n11 109.382
R83 VIN.n19 VIN.n18 103.468
R84 VIN.n3 VIN.t38 91.406
R85 VIN.n38 VIN.t14 90.8602
R86 VIN.n6 VIN.t26 90.8602
R87 VIN VIN.t4 89.2849
R88 VIN VIN.t16 89.2849
R89 VIN VIN.t28 89.2849
R90 VIN.n15 VIN.n14 84.778
R91 VIN VIN.n35 83.5719
R92 VIN VIN.n34 83.5719
R93 VIN VIN.n33 83.5719
R94 VIN VIN.n0 83.5719
R95 VIN VIN.n1 83.5719
R96 VIN VIN.n2 83.5719
R97 VIN.n32 VIN.n31 75.2371
R98 VIN.n16 VIN.n15 61.9487
R99 VIN.n28 VIN.n27 60.6267
R100 VIN.n16 VIN.n12 59.4678
R101 VIN.t41 VIN.t29 51.4291
R102 VIN.n29 VIN.n28 46.2505
R103 VIN.t27 VIN.t39 44.2862
R104 VIN.n18 VIN.n11 40.1093
R105 VIN.n13 VIN.n8 39.9483
R106 VIN.n17 VIN.n16 31.9491
R107 VIN.n27 VIN.t27 17.1844
R108 VIN.n11 VIN.n10 14.8254
R109 VIN.n13 VIN 14.6705
R110 VIN.n30 VIN.n10 13.8129
R111 VIN.n17 VIN 13.0886
R112 VIN.n18 VIN.n17 9.95606
R113 VIN.n15 VIN.n13 8.11358
R114 VIN.n35 VIN.t8 5.7135
R115 VIN.n35 VIN.t6 5.7135
R116 VIN.n34 VIN.t12 5.7135
R117 VIN.n34 VIN.t10 5.7135
R118 VIN.n33 VIN.t20 5.7135
R119 VIN.n33 VIN.t18 5.7135
R120 VIN.n0 VIN.t24 5.7135
R121 VIN.n0 VIN.t22 5.7135
R122 VIN.n1 VIN.t32 5.7135
R123 VIN.n1 VIN.t30 5.7135
R124 VIN.n2 VIN.t36 5.7135
R125 VIN.n2 VIN.t34 5.7135
R126 VIN.n9 VIN 3.88387
R127 VIN VIN.n41 2.31087
R128 VIN.n36 VIN 2.12156
R129 VIN.n36 VIN 1.57572
R130 VIN.n37 VIN 1.57572
R131 VIN.n39 VIN 1.57572
R132 VIN.n40 VIN 1.57572
R133 VIN.n7 VIN 1.57572
R134 VIN.n5 VIN 1.57572
R135 VIN.n4 VIN 1.57572
R136 VIN.n3 VIN 1.57572
R137 VIN.n10 VIN.n9 1.5505
R138 VIN.n38 VIN.n37 0.554667
R139 VIN.n4 VIN.n3 0.5505
R140 VIN.n5 VIN.n4 0.5505
R141 VIN.n7 VIN.n6 0.5505
R142 VIN.n40 VIN.n39 0.546333
R143 VIN.n37 VIN.n36 0.546333
R144 VIN.n32 VIN.n7 0.271333
R145 VIN.n41 VIN.n40 0.271333
R146 VIN.n6 VIN.n5 0.108833
R147 VIN.n39 VIN.n38 0.108833
R148 VIN.n9 VIN 0.0593235
R149 VIN.n41 VIN.n32 0.00466667
R150 VSS.n841 VSS.n386 2.02835e+06
R151 VSS.n859 VSS.n858 16802.4
R152 VSS.n841 VSS.n840 12945.7
R153 VSS.t12 VSS.n841 12843.9
R154 VSS.n2003 VSS.n40 11148.9
R155 VSS.n2018 VSS.n6 10498.9
R156 VSS.n1539 VSS.n1538 6643.2
R157 VSS.n857 VSS 6118.59
R158 VSS.n1323 VSS.n192 5630.05
R159 VSS.n1323 VSS.n1314 5630.05
R160 VSS.n1846 VSS.n5 4858.37
R161 VSS.n847 VSS.n846 3282.89
R162 VSS.n1542 VSS.n1541 3242.67
R163 VSS.n1542 VSS.n1118 3178.67
R164 VSS.n1541 VSS.n1540 3136
R165 VSS.n1540 VSS.n1539 3093.33
R166 VSS.n1118 VSS.n1117 2752.62
R167 VSS.n2003 VSS.n5 2360.72
R168 VSS.n857 VSS 2039.53
R169 VSS.n1117 VSS.n381 2024.28
R170 VSS.n783 VSS.n381 1825.1
R171 VSS.n1533 VSS.n1135 1221.1
R172 VSS.n1113 VSS.n1112 1007.63
R173 VSS.n1112 VSS.n1111 1007.63
R174 VSS.n1111 VSS.n387 1007.63
R175 VSS.n1105 VSS.n387 1007.63
R176 VSS.n1105 VSS.n1104 1007.63
R177 VSS.n396 VSS.n389 1007.63
R178 VSS.n397 VSS.n396 1007.63
R179 VSS.n397 VSS.n390 1007.63
R180 VSS.n403 VSS.n390 1007.63
R181 VSS.n404 VSS.n403 1007.63
R182 VSS.n1150 VSS.n194 1007.63
R183 VSS.n1150 VSS.n1143 1007.63
R184 VSS.n1156 VSS.n1143 1007.63
R185 VSS.n1157 VSS.n1156 1007.63
R186 VSS.n1518 VSS.n1157 1007.63
R187 VSS.n1524 VSS.n1141 1007.63
R188 VSS.n1525 VSS.n1524 1007.63
R189 VSS.n1526 VSS.n1525 1007.63
R190 VSS.n1526 VSS.n1136 1007.63
R191 VSS.n1532 VSS.n1136 1007.63
R192 VSS.n1405 VSS.n1135 968.808
R193 VSS.n1475 VSS.n1158 908.258
R194 VSS.n1475 VSS.n1474 908.258
R195 VSS.n1474 VSS.n1473 908.258
R196 VSS.n1473 VSS.n1176 908.258
R197 VSS.n1176 VSS.n1159 908.258
R198 VSS.n1203 VSS.n1160 908.258
R199 VSS.n1223 VSS.n1203 908.258
R200 VSS.n1407 VSS.n1223 908.258
R201 VSS.n1407 VSS.n1406 908.258
R202 VSS.n1406 VSS.n1405 908.258
R203 VSS.n1785 VSS.n213 876.106
R204 VSS.n1756 VSS.n213 876.106
R205 VSS.n1778 VSS.n1756 876.106
R206 VSS.n1778 VSS.n1777 876.106
R207 VSS.n1777 VSS.n112 876.106
R208 VSS.n1770 VSS.n121 876.106
R209 VSS.n1770 VSS.n1769 876.106
R210 VSS.n1769 VSS.n1768 876.106
R211 VSS.n1768 VSS.n111 876.106
R212 VSS.n1967 VSS.n111 876.106
R213 VSS.n984 VSS.n949 872.247
R214 VSS.n984 VSS.n983 872.247
R215 VSS.n983 VSS.n982 872.247
R216 VSS.n982 VSS.n955 872.247
R217 VSS.n955 VSS.n405 872.247
R218 VSS.n974 VSS.n406 872.247
R219 VSS.n974 VSS.n973 872.247
R220 VSS.n973 VSS.n972 872.247
R221 VSS.n972 VSS.n969 872.247
R222 VSS.n969 VSS.n410 872.247
R223 VSS.n1058 VSS.n454 872.247
R224 VSS.n1059 VSS.n1058 872.247
R225 VSS.n1059 VSS.n450 872.247
R226 VSS.n1065 VSS.n450 872.247
R227 VSS.n1065 VSS.n411 872.247
R228 VSS.n1072 VSS.n412 872.247
R229 VSS.n1073 VSS.n1072 872.247
R230 VSS.n1073 VSS.n442 872.247
R231 VSS.n1080 VSS.n442 872.247
R232 VSS.n1080 VSS.n413 872.247
R233 VSS.n2018 VSS.n5 759.029
R234 VSS.t25 VSS.n389 682.952
R235 VSS.t34 VSS.n1141 682.952
R236 VSS.t34 VSS.n1 136.083
R237 VSS.n195 VSS.n113 642.553
R238 VSS.n1355 VSS.n195 638.298
R239 VSS.t34 VSS.n122 212.635
R240 VSS.n1087 VSS.n1086 629.801
R241 VSS.n1086 VSS.n438 602.707
R242 VSS.n12 VSS.n10 600.524
R243 VSS.t34 VSS.n121 593.806
R244 VSS.t25 VSS.n406 591.189
R245 VSS.t25 VSS.n412 591.189
R246 VSS.n857 VSS.n856 585
R247 VSS.n858 VSS.n857 585
R248 VSS.n1030 VSS.n944 585
R249 VSS.n944 VSS.n943 585
R250 VSS.n1032 VSS.n1031 585
R251 VSS.n1033 VSS.n1032 585
R252 VSS.n942 VSS.n941 585
R253 VSS.n1034 VSS.n942 585
R254 VSS.n1037 VSS.n1036 585
R255 VSS.n1036 VSS.n1035 585
R256 VSS.n1038 VSS.n940 585
R257 VSS.n940 VSS.n939 585
R258 VSS.n1040 VSS.n1039 585
R259 VSS.n1041 VSS.n1040 585
R260 VSS.n938 VSS.n937 585
R261 VSS.n1042 VSS.n938 585
R262 VSS.n1045 VSS.n1044 585
R263 VSS.n1044 VSS.n1043 585
R264 VSS.n1046 VSS.n935 585
R265 VSS.n935 VSS.n934 585
R266 VSS.n1048 VSS.n1047 585
R267 VSS.n1049 VSS.n1048 585
R268 VSS.n936 VSS.n458 585
R269 VSS.n1050 VSS.n458 585
R270 VSS.n1052 VSS.n459 585
R271 VSS.n1052 VSS.n1051 585
R272 VSS.n989 VSS.n945 585
R273 VSS.n990 VSS.n989 585
R274 VSS.n967 VSS.n314 585
R275 VSS.n972 VSS.n967 585
R276 VSS.n966 VSS.n965 585
R277 VSS.n973 VSS.n966 585
R278 VSS.n964 VSS.n962 585
R279 VSS.n974 VSS.n964 585
R280 VSS.n963 VSS.n960 585
R281 VSS.n963 VSS.n406 585
R282 VSS.n978 VSS.n959 585
R283 VSS.n959 VSS.n405 585
R284 VSS.n979 VSS.n958 585
R285 VSS.n958 VSS.n955 585
R286 VSS.n980 VSS.n954 585
R287 VSS.n982 VSS.n954 585
R288 VSS.n957 VSS.n953 585
R289 VSS.n983 VSS.n953 585
R290 VSS.n951 VSS.n950 585
R291 VSS.n984 VSS.n950 585
R292 VSS.n988 VSS.n987 585
R293 VSS.n988 VSS.n949 585
R294 VSS.n992 VSS.n945 585
R295 VSS.n993 VSS.n992 585
R296 VSS.n987 VSS.n986 585
R297 VSS.n986 VSS.n949 585
R298 VSS.n985 VSS.n951 585
R299 VSS.n985 VSS.n984 585
R300 VSS.n957 VSS.n952 585
R301 VSS.n983 VSS.n952 585
R302 VSS.n981 VSS.n980 585
R303 VSS.n982 VSS.n981 585
R304 VSS.n979 VSS.n956 585
R305 VSS.n956 VSS.n955 585
R306 VSS.n978 VSS.n977 585
R307 VSS.n977 VSS.n405 585
R308 VSS.n976 VSS.n960 585
R309 VSS.n976 VSS.n406 585
R310 VSS.n975 VSS.n962 585
R311 VSS.n975 VSS.n974 585
R312 VSS.n965 VSS.n961 585
R313 VSS.n973 VSS.n961 585
R314 VSS.n971 VSS.n314 585
R315 VSS.n972 VSS.n971 585
R316 VSS.n803 VSS.n410 585
R317 VSS.n969 VSS.n968 585
R318 VSS.n970 VSS.n969 585
R319 VSS.n410 VSS.n409 585
R320 VSS.n187 VSS.n182 585
R321 VSS.n181 VSS.n172 585
R322 VSS.n1810 VSS.n1809 585
R323 VSS.n1812 VSS.n171 585
R324 VSS.n1814 VSS.n1813 585
R325 VSS.n163 VSS.n137 585
R326 VSS.n1824 VSS.n1823 585
R327 VSS.n1826 VSS.n162 585
R328 VSS.n1828 VSS.n1827 585
R329 VSS.n1743 VSS.n1742 585
R330 VSS.n1225 VSS.n1224 585
R331 VSS.n1406 VSS.n1225 585
R332 VSS.n1409 VSS.n1200 585
R333 VSS.n1407 VSS.n1200 585
R334 VSS.n1222 VSS.n1199 585
R335 VSS.n1223 VSS.n1222 585
R336 VSS.n1221 VSS.n1220 585
R337 VSS.n1221 VSS.n1203 585
R338 VSS.n1217 VSS.n1204 585
R339 VSS.n1204 VSS.n1160 585
R340 VSS.n1211 VSS.n1210 585
R341 VSS.n1210 VSS.n1159 585
R342 VSS.n1209 VSS.n1180 585
R343 VSS.n1209 VSS.n1176 585
R344 VSS.n1471 VSS.n1175 585
R345 VSS.n1473 VSS.n1175 585
R346 VSS.n1178 VSS.n1174 585
R347 VSS.n1474 VSS.n1174 585
R348 VSS.n1477 VSS.n1171 585
R349 VSS.n1475 VSS.n1171 585
R350 VSS.n1224 VSS.n1202 585
R351 VSS.n1406 VSS.n1202 585
R352 VSS.n1409 VSS.n1408 585
R353 VSS.n1408 VSS.n1407 585
R354 VSS.n1201 VSS.n1199 585
R355 VSS.n1223 VSS.n1201 585
R356 VSS.n1220 VSS.n1219 585
R357 VSS.n1219 VSS.n1203 585
R358 VSS.n1218 VSS.n1217 585
R359 VSS.n1218 VSS.n1160 585
R360 VSS.n1211 VSS.n1207 585
R361 VSS.n1207 VSS.n1159 585
R362 VSS.n1180 VSS.n1177 585
R363 VSS.n1177 VSS.n1176 585
R364 VSS.n1472 VSS.n1471 585
R365 VSS.n1473 VSS.n1472 585
R366 VSS.n1178 VSS.n1173 585
R367 VSS.n1474 VSS.n1173 585
R368 VSS.n1477 VSS.n1476 585
R369 VSS.n1476 VSS.n1475 585
R370 VSS.n1514 VSS.n188 585
R371 VSS.n1513 VSS.n1512 585
R372 VSS.n1510 VSS.n1483 585
R373 VSS.n1508 VSS.n1507 585
R374 VSS.n1504 VSS.n1484 585
R375 VSS.n1501 VSS.n1500 585
R376 VSS.n1498 VSS.n1485 585
R377 VSS.n1496 VSS.n1495 585
R378 VSS.n1492 VSS.n1486 585
R379 VSS.n1489 VSS.n1488 585
R380 VSS.n313 VSS.n311 585
R381 VSS.n311 VSS.n118 585
R382 VSS.n317 VSS.n313 585
R383 VSS.n1490 VSS.n1489 585
R384 VSS.n1492 VSS.n1491 585
R385 VSS.n1495 VSS.n1494 585
R386 VSS.n1493 VSS.n1485 585
R387 VSS.n1502 VSS.n1501 585
R388 VSS.n1504 VSS.n1503 585
R389 VSS.n1507 VSS.n1506 585
R390 VSS.n1505 VSS.n1483 585
R391 VSS.n1513 VSS.n1482 585
R392 VSS.n1515 VSS.n1514 585
R393 VSS.n1628 VSS.n1627 585
R394 VSS.n820 VSS.n819 585
R395 VSS.n818 VSS.n816 585
R396 VSS.n801 VSS.n793 585
R397 VSS.n829 VSS.n828 585
R398 VSS.n831 VSS.n792 585
R399 VSS.n833 VSS.n832 585
R400 VSS.n790 VSS.n290 585
R401 VSS.n789 VSS.n289 585
R402 VSS.n285 VSS.n281 585
R403 VSS.n1696 VSS.n1695 585
R404 VSS.n1626 VSS.n1625 585
R405 VSS.n1626 VSS.n198 585
R406 VSS.n1546 VSS.n350 585
R407 VSS.n367 VSS.n349 585
R408 VSS.n372 VSS.n368 585
R409 VSS.n364 VSS.n363 585
R410 VSS.n360 VSS.n355 585
R411 VSS.n353 VSS.n328 585
R412 VSS.n1609 VSS.n327 585
R413 VSS.n323 VSS.n319 585
R414 VSS.n1615 VSS.n1614 585
R415 VSS.n1617 VSS.n318 585
R416 VSS.n1618 VSS.n315 585
R417 VSS.n1618 VSS.n280 585
R418 VSS.n1621 VSS.n1620 585
R419 VSS.n1620 VSS.n198 585
R420 VSS.n804 VSS.n309 585
R421 VSS.n806 VSS.n308 585
R422 VSS.n823 VSS.n822 585
R423 VSS.n825 VSS.n802 585
R424 VSS.n827 VSS.n826 585
R425 VSS.n799 VSS.n798 585
R426 VSS.n797 VSS.n787 585
R427 VSS.n786 VSS.n288 585
R428 VSS.n1690 VSS.n1689 585
R429 VSS.n1692 VSS.n286 585
R430 VSS.n1694 VSS.n1693 585
R431 VSS.n1546 VSS.n1545 585
R432 VSS.n374 VSS.n349 585
R433 VSS.n373 VSS.n372 585
R434 VSS.n363 VSS.n362 585
R435 VSS.n361 VSS.n360 585
R436 VSS.n328 VSS.n324 585
R437 VSS.n1610 VSS.n1609 585
R438 VSS.n1612 VSS.n323 585
R439 VSS.n1614 VSS.n1613 585
R440 VSS.n407 VSS.n318 585
R441 VSS.n408 VSS.n315 585
R442 VSS.n408 VSS.n287 585
R443 VSS.n436 VSS.n423 585
R444 VSS.n1101 VSS.n1100 585
R445 VSS.n1094 VSS.n422 585
R446 VSS.n573 VSS.n572 585
R447 VSS.n581 VSS.n580 585
R448 VSS.n583 VSS.n582 585
R449 VSS.n564 VSS.n563 585
R450 VSS.n562 VSS.n561 585
R451 VSS.n595 VSS.n594 585
R452 VSS.n597 VSS.n596 585
R453 VSS.n1089 VSS.n425 585
R454 VSS.n1090 VSS.n424 585
R455 VSS.n1093 VSS.n1092 585
R456 VSS.n574 VSS.n429 585
R457 VSS.n571 VSS.n568 585
R458 VSS.n585 VSS.n584 585
R459 VSS.n588 VSS.n587 585
R460 VSS.n566 VSS.n491 585
R461 VSS.n490 VSS.n487 585
R462 VSS.n599 VSS.n598 585
R463 VSS.n672 VSS.n663 585
R464 VSS.n732 VSS.n731 585
R465 VSS.n734 VSS.n661 585
R466 VSS.n736 VSS.n735 585
R467 VSS.n658 VSS.n650 585
R468 VSS.n746 VSS.n745 585
R469 VSS.n748 VSS.n649 585
R470 VSS.n749 VSS.n623 585
R471 VSS.n751 VSS.n622 585
R472 VSS.n753 VSS.n752 585
R473 VSS.n727 VSS.n726 585
R474 VSS.n730 VSS.n729 585
R475 VSS.n671 VSS.n670 585
R476 VSS.n659 VSS.n657 585
R477 VSS.n741 VSS.n740 585
R478 VSS.n744 VSS.n743 585
R479 VSS.n656 VSS.n655 585
R480 VSS.n647 VSS.n621 585
R481 VSS.n762 VSS.n761 585
R482 VSS.n764 VSS.n620 585
R483 VSS.n1763 VSS.n58 585
R484 VSS.n1763 VSS.n111 585
R485 VSS.n1766 VSS.n1764 585
R486 VSS.n1768 VSS.n1764 585
R487 VSS.n1765 VSS.n1762 585
R488 VSS.n1769 VSS.n1762 585
R489 VSS.n1761 VSS.n1760 585
R490 VSS.n1770 VSS.n1761 585
R491 VSS.n1758 VSS.n1757 585
R492 VSS.n1757 VSS.n121 585
R493 VSS.n1775 VSS.n1774 585
R494 VSS.n1775 VSS.n112 585
R495 VSS.n1776 VSS.n1754 585
R496 VSS.n1777 VSS.n1776 585
R497 VSS.n1780 VSS.n1753 585
R498 VSS.n1778 VSS.n1753 585
R499 VSS.n1781 VSS.n1752 585
R500 VSS.n1756 VSS.n1752 585
R501 VSS.n1782 VSS.n211 585
R502 VSS.n213 VSS.n211 585
R503 VSS.n1786 VSS.n212 585
R504 VSS.n1786 VSS.n1785 585
R505 VSS.n210 VSS.n208 585
R506 VSS.n210 VSS.n122 585
R507 VSS.n1788 VSS.n1787 585
R508 VSS.n1787 VSS.n196 585
R509 VSS.n1790 VSS.n1789 585
R510 VSS.n724 VSS.n207 585
R511 VSS.n1740 VSS.n1739 585
R512 VSS.n1741 VSS.n215 585
R513 VSS.n1741 VSS.n120 585
R514 VSS.n1728 VSS.n206 585
R515 VSS.n1731 VSS.n1730 585
R516 VSS.n1726 VSS.n1725 585
R517 VSS.n1724 VSS.n1723 585
R518 VSS.n1716 VSS.n274 585
R519 VSS.n1718 VSS.n1717 585
R520 VSS.n1709 VSS.n275 585
R521 VSS.n1711 VSS.n1710 585
R522 VSS.n1702 VSS.n276 585
R523 VSS.n1704 VSS.n1703 585
R524 VSS.n431 VSS.n277 585
R525 VSS.n1701 VSS.n1700 585
R526 VSS.n1706 VSS.n1705 585
R527 VSS.n1708 VSS.n1707 585
R528 VSS.n1713 VSS.n1712 585
R529 VSS.n1715 VSS.n1714 585
R530 VSS.n1720 VSS.n1719 585
R531 VSS.n1722 VSS.n1721 585
R532 VSS.n273 VSS.n272 585
R533 VSS.n1733 VSS.n1732 585
R534 VSS.n1729 VSS.n271 585
R535 VSS.n1727 VSS.n266 585
R536 VSS.n435 VSS.n433 585
R537 VSS.n435 VSS.n434 585
R538 VSS.n1698 VSS.n279 585
R539 VSS.n432 VSS.n278 585
R540 VSS.n278 VSS.n198 585
R541 VSS.n1078 VSS.n439 585
R542 VSS.n1078 VSS.n413 585
R543 VSS.n1079 VSS.n441 585
R544 VSS.n1080 VSS.n1079 585
R545 VSS.n1081 VSS.n441 585
R546 VSS.n1081 VSS.n1080 585
R547 VSS.n1082 VSS.n439 585
R548 VSS.n1082 VSS.n413 585
R549 VSS.n1084 VSS.n1083 585
R550 VSS.n456 VSS.n455 585
R551 VSS.n931 VSS.n455 585
R552 VSS.n1077 VSS.n1076 585
R553 VSS.n1077 VSS.n442 585
R554 VSS.n1075 VSS.n443 585
R555 VSS.n1073 VSS.n443 585
R556 VSS.n1071 VSS.n444 585
R557 VSS.n1072 VSS.n1071 585
R558 VSS.n1070 VSS.n1069 585
R559 VSS.n1070 VSS.n412 585
R560 VSS.n447 VSS.n446 585
R561 VSS.n446 VSS.n411 585
R562 VSS.n1064 VSS.n449 585
R563 VSS.n1065 VSS.n1064 585
R564 VSS.n1063 VSS.n1062 585
R565 VSS.n1063 VSS.n450 585
R566 VSS.n1061 VSS.n451 585
R567 VSS.n1059 VSS.n451 585
R568 VSS.n1057 VSS.n452 585
R569 VSS.n1058 VSS.n1057 585
R570 VSS.n1056 VSS.n1055 585
R571 VSS.n1056 VSS.n454 585
R572 VSS.n457 VSS.n456 585
R573 VSS.n933 VSS.n457 585
R574 VSS.n1055 VSS.n1054 585
R575 VSS.n1054 VSS.n454 585
R576 VSS.n453 VSS.n452 585
R577 VSS.n1058 VSS.n453 585
R578 VSS.n1061 VSS.n1060 585
R579 VSS.n1060 VSS.n1059 585
R580 VSS.n1062 VSS.n448 585
R581 VSS.n450 VSS.n448 585
R582 VSS.n1066 VSS.n449 585
R583 VSS.n1066 VSS.n1065 585
R584 VSS.n1067 VSS.n447 585
R585 VSS.n1067 VSS.n411 585
R586 VSS.n1069 VSS.n1068 585
R587 VSS.n1068 VSS.n412 585
R588 VSS.n445 VSS.n444 585
R589 VSS.n1072 VSS.n445 585
R590 VSS.n1075 VSS.n1074 585
R591 VSS.n1074 VSS.n1073 585
R592 VSS.n1076 VSS.n440 585
R593 VSS.n442 VSS.n440 585
R594 VSS.n929 VSS.n928 585
R595 VSS.n930 VSS.n929 585
R596 VSS.n926 VSS.n461 585
R597 VSS.n461 VSS.n460 585
R598 VSS.n925 VSS.n924 585
R599 VSS.n924 VSS.n923 585
R600 VSS.n463 VSS.n462 585
R601 VSS.n922 VSS.n463 585
R602 VSS.n920 VSS.n919 585
R603 VSS.n921 VSS.n920 585
R604 VSS.n918 VSS.n464 585
R605 VSS.n914 VSS.n464 585
R606 VSS.n917 VSS.n916 585
R607 VSS.n916 VSS.n915 585
R608 VSS.n466 VSS.n465 585
R609 VSS.n913 VSS.n466 585
R610 VSS.n911 VSS.n910 585
R611 VSS.n912 VSS.n911 585
R612 VSS.n909 VSS.n468 585
R613 VSS.n468 VSS.n467 585
R614 VSS.n907 VSS.n906 585
R615 VSS.n906 VSS.n905 585
R616 VSS.n904 VSS.n469 585
R617 VSS.n904 VSS.n414 585
R618 VSS.n1005 VSS.n1004 585
R619 VSS.n1004 VSS.n1003 585
R620 VSS.n1007 VSS.n1006 585
R621 VSS.n1008 VSS.n1007 585
R622 VSS.n1001 VSS.n1000 585
R623 VSS.n1009 VSS.n1001 585
R624 VSS.n1012 VSS.n1011 585
R625 VSS.n1011 VSS.n1010 585
R626 VSS.n1013 VSS.n999 585
R627 VSS.n999 VSS.n998 585
R628 VSS.n1015 VSS.n1014 585
R629 VSS.n1016 VSS.n1015 585
R630 VSS.n996 VSS.n995 585
R631 VSS.n1017 VSS.n996 585
R632 VSS.n1020 VSS.n1019 585
R633 VSS.n1019 VSS.n1018 585
R634 VSS.n1021 VSS.n994 585
R635 VSS.n997 VSS.n994 585
R636 VSS.n1023 VSS.n1022 585
R637 VSS.n1024 VSS.n1023 585
R638 VSS.n948 VSS.n946 585
R639 VSS.n1025 VSS.n948 585
R640 VSS.n1028 VSS.n1027 585
R641 VSS.n1027 VSS.n1026 585
R642 VSS.n384 VSS.n382 585
R643 VSS.n1002 VSS.n384 585
R644 VSS.n400 VSS.n391 585
R645 VSS.n391 VSS.n390 585
R646 VSS.n399 VSS.n398 585
R647 VSS.n398 VSS.n397 585
R648 VSS.n395 VSS.n392 585
R649 VSS.n396 VSS.n395 585
R650 VSS.n394 VSS.n393 585
R651 VSS.n394 VSS.n389 585
R652 VSS.n388 VSS.n380 585
R653 VSS.n1104 VSS.n388 585
R654 VSS.n1106 VSS.n379 585
R655 VSS.n1106 VSS.n1105 585
R656 VSS.n1108 VSS.n1107 585
R657 VSS.n1107 VSS.n387 585
R658 VSS.n1110 VSS.n1109 585
R659 VSS.n1111 VSS.n1110 585
R660 VSS.n385 VSS.n383 585
R661 VSS.n1112 VSS.n385 585
R662 VSS.n1115 VSS.n1114 585
R663 VSS.n1114 VSS.n1113 585
R664 VSS.n1146 VSS.n378 585
R665 VSS.n1146 VSS.n280 585
R666 VSS.n1148 VSS.n1147 585
R667 VSS.n1148 VSS.n198 585
R668 VSS.n377 VSS.n376 585
R669 VSS.n404 VSS.n376 585
R670 VSS.n402 VSS.n401 585
R671 VSS.n403 VSS.n402 585
R672 VSS.n1544 VSS.n1543 585
R673 VSS.n1544 VSS.n287 585
R674 VSS.n1529 VSS.n1137 585
R675 VSS.n1137 VSS.n1136 585
R676 VSS.n1528 VSS.n1527 585
R677 VSS.n1527 VSS.n1526 585
R678 VSS.n1140 VSS.n1139 585
R679 VSS.n1525 VSS.n1140 585
R680 VSS.n1523 VSS.n1522 585
R681 VSS.n1524 VSS.n1523 585
R682 VSS.n1521 VSS.n1520 585
R683 VSS.n1520 VSS.n1141 585
R684 VSS.n1519 VSS.n1120 585
R685 VSS.n1519 VSS.n1518 585
R686 VSS.n1142 VSS.n1119 585
R687 VSS.n1157 VSS.n1142 585
R688 VSS.n1155 VSS.n1154 585
R689 VSS.n1156 VSS.n1155 585
R690 VSS.n1153 VSS.n1144 585
R691 VSS.n1144 VSS.n1143 585
R692 VSS.n1152 VSS.n1151 585
R693 VSS.n1151 VSS.n1150 585
R694 VSS.n1149 VSS.n1145 585
R695 VSS.n1149 VSS.n194 585
R696 VSS.n1404 VSS.n1123 585
R697 VSS.n1405 VSS.n1404 585
R698 VSS.n1403 VSS.n1402 585
R699 VSS.n1403 VSS.n1135 585
R700 VSS.n1531 VSS.n1530 585
R701 VSS.n1532 VSS.n1531 585
R702 VSS.n1138 VSS.n1122 585
R703 VSS.n1405 VSS.n1138 585
R704 VSS.n1384 VSS.n1383 585
R705 VSS.n1386 VSS.n1230 585
R706 VSS.n1388 VSS.n1387 585
R707 VSS.n1389 VSS.n1229 585
R708 VSS.n1391 VSS.n1390 585
R709 VSS.n1393 VSS.n1125 585
R710 VSS.n1394 VSS.n1124 585
R711 VSS.n1396 VSS.n1228 585
R712 VSS.n1397 VSS.n1227 585
R713 VSS.n1400 VSS.n1399 585
R714 VSS.n1401 VSS.n1226 585
R715 VSS.n1226 VSS.n1134 585
R716 VSS.n1377 VSS.n1376 585
R717 VSS.n1377 VSS.n1132 585
R718 VSS.n1134 VSS.n1132 585
R719 VSS.n1535 VSS.n1534 585
R720 VSS.n1133 VSS.n1131 585
R721 VSS.n1357 VSS.n1356 585
R722 VSS.n1359 VSS.n1358 585
R723 VSS.n1361 VSS.n1360 585
R724 VSS.n1363 VSS.n1362 585
R725 VSS.n1365 VSS.n1364 585
R726 VSS.n1367 VSS.n1366 585
R727 VSS.n1369 VSS.n1368 585
R728 VSS.n1371 VSS.n1370 585
R729 VSS.n1373 VSS.n1372 585
R730 VSS.n1375 VSS.n1374 585
R731 VSS.n1328 VSS.n1327 585
R732 VSS.n1330 VSS.n1329 585
R733 VSS.n1335 VSS.n1331 585
R734 VSS.n1338 VSS.n1337 585
R735 VSS.n1336 VSS.n1324 585
R736 VSS.n1344 VSS.n1343 585
R737 VSS.n1346 VSS.n1345 585
R738 VSS.n1322 VSS.n1321 585
R739 VSS.n1353 VSS.n1352 585
R740 VSS.n1320 VSS.n1311 585
R741 VSS.n1381 VSS.n1312 585
R742 VSS.n1479 VSS.n1169 585
R743 VSS.n1169 VSS.n1158 585
R744 VSS.n1480 VSS.n1161 585
R745 VSS.n1517 VSS.n1161 585
R746 VSS.n1796 VSS.n1795 585
R747 VSS.n1796 VSS.n118 585
R748 VSS.n1798 VSS.n1797 585
R749 VSS.n1797 VSS.n120 585
R750 VSS.n1481 VSS.n1480 585
R751 VSS.n1479 VSS.n1167 585
R752 VSS.n1167 VSS.n1158 585
R753 VSS.n1794 VSS.n1793 585
R754 VSS.n1378 VSS.n1377 585
R755 VSS.n1381 VSS.n1380 585
R756 VSS.n1313 VSS.n1311 585
R757 VSS.n1352 VSS.n1351 585
R758 VSS.n1349 VSS.n1322 585
R759 VSS.n1347 VSS.n1346 585
R760 VSS.n1343 VSS.n1342 585
R761 VSS.n1340 VSS.n1324 585
R762 VSS.n1339 VSS.n1338 585
R763 VSS.n1335 VSS.n1334 585
R764 VSS.n1333 VSS.n1329 585
R765 VSS.n1328 VSS.n193 585
R766 VSS.n191 VSS.n185 585
R767 VSS.n184 VSS.n180 585
R768 VSS.n1805 VSS.n1804 585
R769 VSS.n1808 VSS.n1807 585
R770 VSS.n179 VSS.n178 585
R771 VSS.n167 VSS.n166 585
R772 VSS.n1817 VSS.n1816 585
R773 VSS.n1819 VSS.n136 585
R774 VSS.n1821 VSS.n1820 585
R775 VSS.n1746 VSS.n159 585
R776 VSS.n1747 VSS.n158 585
R777 VSS.n1749 VSS.n1745 585
R778 VSS.n1738 VSS.n214 585
R779 VSS.n214 VSS.n119 585
R780 VSS.n1784 VSS.n212 585
R781 VSS.n1785 VSS.n1784 585
R782 VSS.n1783 VSS.n1782 585
R783 VSS.n1783 VSS.n213 585
R784 VSS.n1781 VSS.n1751 585
R785 VSS.n1756 VSS.n1751 585
R786 VSS.n1780 VSS.n1779 585
R787 VSS.n1779 VSS.n1778 585
R788 VSS.n1755 VSS.n1754 585
R789 VSS.n1777 VSS.n1755 585
R790 VSS.n1774 VSS.n1773 585
R791 VSS.n1773 VSS.n112 585
R792 VSS.n1772 VSS.n1758 585
R793 VSS.n1772 VSS.n121 585
R794 VSS.n1771 VSS.n1760 585
R795 VSS.n1771 VSS.n1770 585
R796 VSS.n1765 VSS.n1759 585
R797 VSS.n1769 VSS.n1759 585
R798 VSS.n1767 VSS.n1766 585
R799 VSS.n1768 VSS.n1767 585
R800 VSS.n110 VSS.n58 585
R801 VSS.n111 VSS.n110 585
R802 VSS.n116 VSS.n109 585
R803 VSS.n117 VSS.n116 585
R804 VSS.n10 VSS.n8 585
R805 VSS.n2016 VSS.n2015 585
R806 VSS.n2017 VSS.n2016 585
R807 VSS.n1848 VSS.n9 585
R808 VSS.n9 VSS.n7 585
R809 VSS.n1851 VSS.n1847 585
R810 VSS.n1856 VSS.n1847 585
R811 VSS.n1858 VSS.n1855 585
R812 VSS.n1858 VSS.n1857 585
R813 VSS.n1860 VSS.n1859 585
R814 VSS.n1859 VSS.n115 585
R815 VSS.n1845 VSS.n1841 585
R816 VSS.n1845 VSS.n114 585
R817 VSS.n1844 VSS.n1840 585
R818 VSS.n1844 VSS.n1843 585
R819 VSS.n1837 VSS.n37 585
R820 VSS.n39 VSS.n37 585
R821 VSS.n2007 VSS.n2006 585
R822 VSS.n2006 VSS.n2005 585
R823 VSS.n36 VSS.n34 585
R824 VSS.n38 VSS.n36 585
R825 VSS.n1965 VSS.n1964 585
R826 VSS.n1966 VSS.n1965 585
R827 VSS.n1971 VSS.n57 585
R828 VSS.n1967 VSS.n57 585
R829 VSS.n1973 VSS.n1972 585
R830 VSS.n1975 VSS.n56 585
R831 VSS.n1977 VSS.n1976 585
R832 VSS.n52 VSS.n50 585
R833 VSS.n1984 VSS.n1983 585
R834 VSS.n1986 VSS.n44 585
R835 VSS.n1987 VSS.n41 585
R836 VSS.n1990 VSS.n1989 585
R837 VSS.n1886 VSS.n48 585
R838 VSS.n1960 VSS.n1958 585
R839 VSS.n1962 VSS.n1961 585
R840 VSS.n1963 VSS.n125 585
R841 VSS.n1969 VSS.n1968 585
R842 VSS.n1968 VSS.n1967 585
R843 VSS.n771 VSS.n770 585
R844 VSS.n770 VSS.n617 585
R845 VSS.n769 VSS.n767 585
R846 VSS.n769 VSS.n768 585
R847 VSS.n134 VSS.n133 585
R848 VSS.n133 VSS.n132 585
R849 VSS.n1869 VSS.n1868 585
R850 VSS.n1870 VSS.n1869 585
R851 VSS.n131 VSS.n130 585
R852 VSS.n1871 VSS.n131 585
R853 VSS.n1874 VSS.n1873 585
R854 VSS.n1873 VSS.n1872 585
R855 VSS.n1875 VSS.n129 585
R856 VSS.n129 VSS.n128 585
R857 VSS.n1877 VSS.n1876 585
R858 VSS.n1878 VSS.n1877 585
R859 VSS.n127 VSS.n126 585
R860 VSS.n1879 VSS.n127 585
R861 VSS.n1882 VSS.n1881 585
R862 VSS.n1881 VSS.n1880 585
R863 VSS.n1883 VSS.n124 585
R864 VSS.n124 VSS.n123 585
R865 VSS.n766 VSS.n765 585
R866 VSS.n765 VSS.n122 585
R867 VSS.n773 VSS.n772 585
R868 VSS.n774 VSS.n773 585
R869 VSS.n777 VSS.n776 585
R870 VSS.n776 VSS.n775 585
R871 VSS.n616 VSS.n615 585
R872 VSS.n873 VSS.n872 585
R873 VSS.n872 VSS.n484 585
R874 VSS.n871 VSS.n603 585
R875 VSS.n871 VSS.n870 585
R876 VSS.n607 VSS.n604 585
R877 VSS.n869 VSS.n604 585
R878 VSS.n867 VSS.n866 585
R879 VSS.n868 VSS.n867 585
R880 VSS.n865 VSS.n606 585
R881 VSS.n606 VSS.n605 585
R882 VSS.n864 VSS.n863 585
R883 VSS.n863 VSS.n199 585
R884 VSS.n862 VSS.n609 585
R885 VSS.n862 VSS.n200 585
R886 VSS.n861 VSS.n611 585
R887 VSS.n861 VSS.n860 585
R888 VSS.n614 VSS.n610 585
R889 VSS.n782 VSS.n610 585
R890 VSS.n780 VSS.n779 585
R891 VSS.n781 VSS.n780 585
R892 VSS.n778 VSS.n613 585
R893 VSS.n613 VSS.n612 585
R894 VSS.n602 VSS.n601 585
R895 VSS.n875 VSS.n874 585
R896 VSS.n876 VSS.n875 585
R897 VSS.n880 VSS.n480 585
R898 VSS.n480 VSS.n479 585
R899 VSS.n879 VSS.n878 585
R900 VSS.n878 VSS.n877 585
R901 VSS.n483 VSS.n482 585
R902 VSS.n890 VSS.n889 585
R903 VSS.n891 VSS.n890 585
R904 VSS.n888 VSS.n475 585
R905 VSS.n475 VSS.n474 585
R906 VSS.n887 VSS.n886 585
R907 VSS.n886 VSS.n885 585
R908 VSS.n481 VSS.n478 585
R909 VSS.n884 VSS.n478 585
R910 VSS.n882 VSS.n881 585
R911 VSS.n883 VSS.n882 585
R912 VSS.n902 VSS.n471 585
R913 VSS.n902 VSS.n901 585
R914 VSS.n900 VSS.n470 585
R915 VSS.n899 VSS.n898 585
R916 VSS.n896 VSS.n472 585
R917 VSS.n894 VSS.n893 585
R918 VSS.n473 VSS.n471 585
R919 VSS.n892 VSS.n473 585
R920 VSS.n1374 VSS.n195 537.946
R921 VSS.n195 VSS.n8 529.372
R922 VSS.n1533 VSS.n1134 514.894
R923 VSS.t9 VSS 485.714
R924 VSS.t34 VSS.n1160 474.312
R925 VSS.n1534 VSS.n1533 465.077
R926 VSS.n0 VSS.t34 149.661
R927 VSS.n2 VSS.n195 1.97021
R928 VSS.t10 VSS.t19 446.584
R929 VSS.n1735 VSS.n197 445.986
R930 VSS.t34 VSS.n196 442.993
R931 VSS.t34 VSS.n1159 433.945
R932 VSS.n1113 VSS.n386 425.445
R933 VSS.t34 VSS.n194 425.445
R934 VSS.n908 VSS.n381 416
R935 VSS.n877 VSS.n876 409.971
R936 VSS.n775 VSS.n774 409.971
R937 VSS.n1785 VSS.n197 369.911
R938 VSS.n991 VSS.n949 368.283
R939 VSS.n932 VSS.n454 368.283
R940 VSS.n991 VSS.n990 361.087
R941 VSS.n933 VSS.n932 358.697
R942 VSS.n993 VSS.n991 358.697
R943 VSS.t7 VSS.t10 354.038
R944 VSS.t4 VSS.n931 330
R945 VSS.t34 VSS.n1355 327.661
R946 VSS.t21 VSS.t7 327.329
R947 VSS.n846 VSS.n843 326.217
R948 VSS.n1104 VSS.t25 324.683
R949 VSS.n1518 VSS.t34 324.683
R950 VSS.t34 VSS.n113 323.404
R951 VSS.t34 VSS.n1134 323.404
R952 VSS.n1850 VSS.n3 308.142
R953 VSS.t34 VSS.n1966 305.284
R954 VSS VSS.n2018 292.5
R955 VSS.n2018 VSS.t13 292.5
R956 VSS.n1002 VSS.n386 289.349
R957 VSS.n1996 VSS.n43 284.928
R958 VSS.n1382 VSS.n1233 284.928
R959 VSS.t34 VSS.n112 282.301
R960 VSS.n1996 VSS.n42 281.55
R961 VSS.n1382 VSS.n1232 281.55
R962 VSS.t25 VSS.n405 281.058
R963 VSS.t25 VSS.n411 281.058
R964 VSS.n785 VSS.n784 279.906
R965 VSS.t25 VSS.n416 263.303
R966 VSS.n415 VSS.t6 262.935
R967 VSS.n1903 VSS.n1902 258.334
R968 VSS.n2012 VSS.n2011 258.334
R969 VSS.n1258 VSS.n1257 258.334
R970 VSS.n1549 VSS.n1548 258.334
R971 VSS.n1631 VSS.n307 258.334
R972 VSS.n1802 VSS.n1801 258.334
R973 VSS.n1415 VSS.n1413 258.334
R974 VSS.n1098 VSS.n426 258.334
R975 VSS.n722 VSS.n721 258.334
R976 VSS.n1741 VSS.n1740 257.466
R977 VSS.n409 VSS.n408 257.466
R978 VSS.n1083 VSS.n1082 257.466
R979 VSS.n1481 VSS.n1167 257.466
R980 VSS.n1376 VSS.n1375 257.466
R981 VSS.n878 VSS.n483 257.466
R982 VSS.n776 VSS.n616 257.466
R983 VSS.n1965 VSS.n125 257.466
R984 VSS.n1624 VSS.n312 254.34
R985 VSS.n1621 VSS.n316 254.34
R986 VSS.n186 VSS.n120 254.34
R987 VSS.n1811 VSS.n120 254.34
R988 VSS.n168 VSS.n120 254.34
R989 VSS.n1825 VSS.n120 254.34
R990 VSS.n160 VSS.n120 254.34
R991 VSS.n1511 VSS.n118 254.34
R992 VSS.n1509 VSS.n118 254.34
R993 VSS.n1499 VSS.n118 254.34
R994 VSS.n1497 VSS.n118 254.34
R995 VSS.n1487 VSS.n118 254.34
R996 VSS.n1517 VSS.n1162 254.34
R997 VSS.n1517 VSS.n1163 254.34
R998 VSS.n1517 VSS.n1164 254.34
R999 VSS.n1517 VSS.n1165 254.34
R1000 VSS.n1517 VSS.n1166 254.34
R1001 VSS.n1517 VSS.n1516 254.34
R1002 VSS.n310 VSS.n280 254.34
R1003 VSS.n817 VSS.n280 254.34
R1004 VSS.n830 VSS.n280 254.34
R1005 VSS.n791 VSS.n280 254.34
R1006 VSS.n788 VSS.n280 254.34
R1007 VSS.n1697 VSS.n280 254.34
R1008 VSS.n366 VSS.n280 254.34
R1009 VSS.n365 VSS.n280 254.34
R1010 VSS.n354 VSS.n280 254.34
R1011 VSS.n326 VSS.n280 254.34
R1012 VSS.n1616 VSS.n280 254.34
R1013 VSS.n805 VSS.n287 254.34
R1014 VSS.n824 VSS.n287 254.34
R1015 VSS.n800 VSS.n287 254.34
R1016 VSS.n796 VSS.n287 254.34
R1017 VSS.n1691 VSS.n287 254.34
R1018 VSS.n287 VSS.n284 254.34
R1019 VSS.n375 VSS.n287 254.34
R1020 VSS.n351 VSS.n287 254.34
R1021 VSS.n358 VSS.n287 254.34
R1022 VSS.n1611 VSS.n287 254.34
R1023 VSS.n322 VSS.n287 254.34
R1024 VSS.n1103 VSS.n1102 254.34
R1025 VSS.n1103 VSS.n421 254.34
R1026 VSS.n1103 VSS.n420 254.34
R1027 VSS.n1103 VSS.n419 254.34
R1028 VSS.n1103 VSS.n418 254.34
R1029 VSS.n1088 VSS.n430 254.34
R1030 VSS.n1091 VSS.n430 254.34
R1031 VSS.n567 VSS.n430 254.34
R1032 VSS.n586 VSS.n430 254.34
R1033 VSS.n565 VSS.n430 254.34
R1034 VSS.n600 VSS.n430 254.34
R1035 VSS.n733 VSS.n646 254.34
R1036 VSS.n660 VSS.n646 254.34
R1037 VSS.n747 VSS.n646 254.34
R1038 VSS.n750 VSS.n646 254.34
R1039 VSS.n646 VSS.n645 254.34
R1040 VSS.n728 VSS.n122 254.34
R1041 VSS.n669 VSS.n122 254.34
R1042 VSS.n742 VSS.n122 254.34
R1043 VSS.n654 VSS.n122 254.34
R1044 VSS.n763 VSS.n122 254.34
R1045 VSS.n1792 VSS.n1791 254.34
R1046 VSS.n662 VSS.n646 254.34
R1047 VSS.n1736 VSS.n1735 254.34
R1048 VSS.n1792 VSS.n205 254.34
R1049 VSS.n1792 VSS.n204 254.34
R1050 VSS.n1792 VSS.n203 254.34
R1051 VSS.n1792 VSS.n202 254.34
R1052 VSS.n1792 VSS.n201 254.34
R1053 VSS.n1735 VSS.n267 254.34
R1054 VSS.n1735 VSS.n268 254.34
R1055 VSS.n1735 VSS.n269 254.34
R1056 VSS.n1735 VSS.n270 254.34
R1057 VSS.n1735 VSS.n1734 254.34
R1058 VSS.n1385 VSS.n1134 254.34
R1059 VSS.n1231 VSS.n1134 254.34
R1060 VSS.n1392 VSS.n1134 254.34
R1061 VSS.n1395 VSS.n1134 254.34
R1062 VSS.n1398 VSS.n1134 254.34
R1063 VSS.n1355 VSS.n1315 254.34
R1064 VSS.n1537 VSS.n1536 254.34
R1065 VSS.n1537 VSS.n1130 254.34
R1066 VSS.n1537 VSS.n1129 254.34
R1067 VSS.n1537 VSS.n1128 254.34
R1068 VSS.n1537 VSS.n1127 254.34
R1069 VSS.n1537 VSS.n1126 254.34
R1070 VSS.n1355 VSS.n1316 254.34
R1071 VSS.n1355 VSS.n1317 254.34
R1072 VSS.n1355 VSS.n1318 254.34
R1073 VSS.n1355 VSS.n1319 254.34
R1074 VSS.n1355 VSS.n1354 254.34
R1075 VSS.n190 VSS.n165 254.34
R1076 VSS.n1806 VSS.n165 254.34
R1077 VSS.n177 VSS.n165 254.34
R1078 VSS.n1818 VSS.n165 254.34
R1079 VSS.n165 VSS.n164 254.34
R1080 VSS.n1748 VSS.n165 254.34
R1081 VSS.n1974 VSS.n49 254.34
R1082 VSS.n55 VSS.n49 254.34
R1083 VSS.n1985 VSS.n49 254.34
R1084 VSS.n1988 VSS.n49 254.34
R1085 VSS.n1959 VSS.n49 254.34
R1086 VSS.n1885 VSS.n49 254.34
R1087 VSS.n1103 VSS.n417 254.34
R1088 VSS.n897 VSS.n471 254.34
R1089 VSS.n895 VSS.n471 254.34
R1090 VSS.n1797 VSS.n1796 251.614
R1091 VSS.n1544 VSS.n376 251.614
R1092 VSS.n804 VSS.n803 251.614
R1093 VSS.n1531 VSS.n1138 251.614
R1094 VSS.n1535 VSS.n1132 251.614
R1095 VSS.n1078 VSS.n438 251.614
R1096 VSS.n1790 VSS.n207 251.614
R1097 VSS.n1973 VSS.n57 251.614
R1098 VSS.n2009 VSS.n33 250
R1099 VSS.n1379 VSS.n113 246.877
R1100 VSS.n1350 VSS.n113 246.877
R1101 VSS.n1348 VSS.n113 246.877
R1102 VSS.n1341 VSS.n113 246.877
R1103 VSS.n1325 VSS.n113 246.877
R1104 VSS.n1332 VSS.n113 246.877
R1105 VSS.t34 VSS.n1158 242.202
R1106 VSS.n1051 VSS.n933 241.523
R1107 VSS.n1026 VSS.n993 241.523
R1108 VSS.n2 VSS.n1517 151.631
R1109 VSS.n931 VSS.n930 229.565
R1110 VSS.n1003 VSS.n1002 229.565
R1111 VSS.n0 VSS.n118 1.99647
R1112 VSS.t31 VSS.n1792 227.483
R1113 VSS.t34 VSS.n119 224.49
R1114 VSS VSS.t11 219.8
R1115 VSS VSS.t20 219.8
R1116 VSS.t25 VSS.n1103 216.657
R1117 VSS.n1378 VSS.n1314 216.617
R1118 VSS.n1793 VSS.n193 216.22
R1119 VSS.n1334 VSS.n1333 216.22
R1120 VSS.n1340 VSS.n1339 216.22
R1121 VSS.n1351 VSS.n1349 216.22
R1122 VSS.n1380 VSS.n1313 216.22
R1123 VSS.n905 VSS.n414 215.218
R1124 VSS.n905 VSS.n467 215.218
R1125 VSS.n912 VSS.n467 215.218
R1126 VSS.n913 VSS.n912 215.218
R1127 VSS.n915 VSS.n913 215.218
R1128 VSS.n922 VSS.n921 215.218
R1129 VSS.n923 VSS.n922 215.218
R1130 VSS.n923 VSS.n460 215.218
R1131 VSS.n930 VSS.n460 215.218
R1132 VSS.n1051 VSS.n1050 215.218
R1133 VSS.n1050 VSS.n1049 215.218
R1134 VSS.n1049 VSS.n934 215.218
R1135 VSS.n1043 VSS.n934 215.218
R1136 VSS.n1041 VSS.n939 215.218
R1137 VSS.n1035 VSS.n939 215.218
R1138 VSS.n1035 VSS.n1034 215.218
R1139 VSS.n1034 VSS.n1033 215.218
R1140 VSS.n1033 VSS.n943 215.218
R1141 VSS.n1026 VSS.n1025 215.218
R1142 VSS.n1025 VSS.n1024 215.218
R1143 VSS.n1018 VSS.n997 215.218
R1144 VSS.n1018 VSS.n1017 215.218
R1145 VSS.n1016 VSS.n998 215.218
R1146 VSS.n1010 VSS.n998 215.218
R1147 VSS.n1010 VSS.n1009 215.218
R1148 VSS.n1008 VSS.n1003 215.218
R1149 VSS.t34 VSS.n120 213.57
R1150 VSS.t34 VSS.n49 213.416
R1151 VSS.t25 VSS.n280 206.107
R1152 VSS VSS.t8 202.4
R1153 VSS.n1699 VSS.n1698 195.049
R1154 VSS.n1027 VSS.n947 195.049
R1155 VSS.n1053 VSS.n1052 195.049
R1156 VSS.n1619 VSS.n1618 195.049
R1157 VSS.n1326 VSS.n1169 195.049
R1158 VSS.n904 VSS.n903 195.049
R1159 VSS.n601 VSS.n485 195.049
R1160 VSS.n765 VSS.n618 195.049
R1161 VSS.n1750 VSS.n1749 195.049
R1162 VSS.n847 VSS.n785 194.065
R1163 VSS.n2005 VSS.n38 192.888
R1164 VSS.n1857 VSS.n1856 192.888
R1165 VSS.n1856 VSS.n7 192.888
R1166 VSS.n2017 VSS.n8 192.888
R1167 VSS.n1374 VSS.n1373 192.888
R1168 VSS.n1373 VSS.n1370 192.888
R1169 VSS.n1370 VSS.n1369 192.888
R1170 VSS.n1369 VSS.n1366 192.888
R1171 VSS.n1366 VSS.n1365 192.888
R1172 VSS.n1362 VSS.n1361 192.888
R1173 VSS.n1361 VSS.n1358 192.888
R1174 VSS.n1358 VSS.n1357 192.888
R1175 VSS.n1357 VSS.n1133 192.888
R1176 VSS.n1534 VSS.n1133 192.888
R1177 VSS.n1627 VSS.n1626 187.249
R1178 VSS.n1004 VSS.n384 187.249
R1179 VSS.n989 VSS.n944 187.249
R1180 VSS.n1148 VSS.n1146 187.249
R1181 VSS.n1404 VSS.n1403 187.249
R1182 VSS.n929 VSS.n455 187.249
R1183 VSS.n1087 VSS.n435 187.249
R1184 VSS.n1787 VSS.n210 187.249
R1185 VSS.n1938 VSS.n1937 185
R1186 VSS.n1939 VSS.n1890 185
R1187 VSS.n1941 VSS.n1940 185
R1188 VSS.n1943 VSS.n1889 185
R1189 VSS.n1946 VSS.n1945 185
R1190 VSS.n1947 VSS.n1888 185
R1191 VSS.n1949 VSS.n1948 185
R1192 VSS.n1951 VSS.n1887 185
R1193 VSS.n1952 VSS.n42 185
R1194 VSS.n1919 VSS.n1895 185
R1195 VSS.n1922 VSS.n1921 185
R1196 VSS.n1923 VSS.n1894 185
R1197 VSS.n1925 VSS.n1924 185
R1198 VSS.n1927 VSS.n1893 185
R1199 VSS.n1930 VSS.n1929 185
R1200 VSS.n1931 VSS.n1892 185
R1201 VSS.n1933 VSS.n1932 185
R1202 VSS.n1935 VSS.n1891 185
R1203 VSS.n1903 VSS.n43 185
R1204 VSS.n1905 VSS.n1900 185
R1205 VSS.n1907 VSS.n1906 185
R1206 VSS.n1908 VSS.n1899 185
R1207 VSS.n1910 VSS.n1909 185
R1208 VSS.n1912 VSS.n1897 185
R1209 VSS.n1914 VSS.n1913 185
R1210 VSS.n1915 VSS.n1896 185
R1211 VSS.n1917 VSS.n1916 185
R1212 VSS.n1293 VSS.n1292 185
R1213 VSS.n1294 VSS.n1245 185
R1214 VSS.n1296 VSS.n1295 185
R1215 VSS.n1298 VSS.n1244 185
R1216 VSS.n1301 VSS.n1300 185
R1217 VSS.n1302 VSS.n1243 185
R1218 VSS.n1304 VSS.n1303 185
R1219 VSS.n1306 VSS.n1242 185
R1220 VSS.n1307 VSS.n1232 185
R1221 VSS.n1274 VSS.n1250 185
R1222 VSS.n1277 VSS.n1276 185
R1223 VSS.n1278 VSS.n1249 185
R1224 VSS.n1280 VSS.n1279 185
R1225 VSS.n1282 VSS.n1248 185
R1226 VSS.n1285 VSS.n1284 185
R1227 VSS.n1286 VSS.n1247 185
R1228 VSS.n1288 VSS.n1287 185
R1229 VSS.n1290 VSS.n1246 185
R1230 VSS.n1258 VSS.n1233 185
R1231 VSS.n1260 VSS.n1255 185
R1232 VSS.n1262 VSS.n1261 185
R1233 VSS.n1263 VSS.n1254 185
R1234 VSS.n1265 VSS.n1264 185
R1235 VSS.n1267 VSS.n1252 185
R1236 VSS.n1269 VSS.n1268 185
R1237 VSS.n1270 VSS.n1251 185
R1238 VSS.n1272 VSS.n1271 185
R1239 VSS.n1586 VSS.n1585 185
R1240 VSS.n1588 VSS.n1587 185
R1241 VSS.n1590 VSS.n1589 185
R1242 VSS.n1592 VSS.n1591 185
R1243 VSS.n1594 VSS.n1593 185
R1244 VSS.n1596 VSS.n1595 185
R1245 VSS.n1598 VSS.n1597 185
R1246 VSS.n1599 VSS.n347 185
R1247 VSS.n1602 VSS.n1601 185
R1248 VSS.n1568 VSS.n1567 185
R1249 VSS.n1570 VSS.n1569 185
R1250 VSS.n1572 VSS.n1571 185
R1251 VSS.n1574 VSS.n1573 185
R1252 VSS.n1576 VSS.n1575 185
R1253 VSS.n1578 VSS.n1577 185
R1254 VSS.n1580 VSS.n1579 185
R1255 VSS.n1582 VSS.n1581 185
R1256 VSS.n1584 VSS.n1583 185
R1257 VSS.n1550 VSS.n1549 185
R1258 VSS.n1552 VSS.n1551 185
R1259 VSS.n1554 VSS.n1553 185
R1260 VSS.n1556 VSS.n1555 185
R1261 VSS.n1558 VSS.n1557 185
R1262 VSS.n1560 VSS.n1559 185
R1263 VSS.n1562 VSS.n1561 185
R1264 VSS.n1564 VSS.n1563 185
R1265 VSS.n1566 VSS.n1565 185
R1266 VSS.n1548 VSS.n1547 185
R1267 VSS.n371 VSS.n370 185
R1268 VSS.n369 VSS.n352 185
R1269 VSS.n357 VSS.n356 185
R1270 VSS.n359 VSS.n330 185
R1271 VSS.n1608 VSS.n1607 185
R1272 VSS.n329 VSS.n325 185
R1273 VSS.n1603 VSS.n321 185
R1274 VSS.n1604 VSS.n320 185
R1275 VSS.n1665 VSS.n1664 185
R1276 VSS.n1667 VSS.n295 185
R1277 VSS.n1670 VSS.n1669 185
R1278 VSS.n1671 VSS.n294 185
R1279 VSS.n1673 VSS.n1672 185
R1280 VSS.n1675 VSS.n293 185
R1281 VSS.n1678 VSS.n1677 185
R1282 VSS.n1679 VSS.n292 185
R1283 VSS.n1681 VSS.n1680 185
R1284 VSS.n1647 VSS.n300 185
R1285 VSS.n1649 VSS.n1648 185
R1286 VSS.n1651 VSS.n1650 185
R1287 VSS.n1654 VSS.n1653 185
R1288 VSS.n1655 VSS.n298 185
R1289 VSS.n1657 VSS.n1656 185
R1290 VSS.n1659 VSS.n297 185
R1291 VSS.n1662 VSS.n1661 185
R1292 VSS.n1663 VSS.n296 185
R1293 VSS.n1631 VSS.n1630 185
R1294 VSS.n1633 VSS.n305 185
R1295 VSS.n1635 VSS.n1634 185
R1296 VSS.n1636 VSS.n304 185
R1297 VSS.n1638 VSS.n1637 185
R1298 VSS.n1640 VSS.n302 185
R1299 VSS.n1642 VSS.n1641 185
R1300 VSS.n1643 VSS.n301 185
R1301 VSS.n1645 VSS.n1644 185
R1302 VSS.n821 VSS.n307 185
R1303 VSS.n815 VSS.n814 185
R1304 VSS.n812 VSS.n795 185
R1305 VSS.n810 VSS.n794 185
R1306 VSS.n809 VSS.n807 185
R1307 VSS.n834 VSS.n291 185
R1308 VSS.n1688 VSS.n1687 185
R1309 VSS.n1685 VSS.n1684 185
R1310 VSS.n1683 VSS.n283 185
R1311 VSS.n250 VSS.n249 185
R1312 VSS.n252 VSS.n251 185
R1313 VSS.n254 VSS.n253 185
R1314 VSS.n256 VSS.n255 185
R1315 VSS.n258 VSS.n257 185
R1316 VSS.n260 VSS.n259 185
R1317 VSS.n262 VSS.n261 185
R1318 VSS.n264 VSS.n263 185
R1319 VSS.n265 VSS.n156 185
R1320 VSS.n232 VSS.n231 185
R1321 VSS.n234 VSS.n233 185
R1322 VSS.n236 VSS.n235 185
R1323 VSS.n238 VSS.n237 185
R1324 VSS.n240 VSS.n239 185
R1325 VSS.n242 VSS.n241 185
R1326 VSS.n244 VSS.n243 185
R1327 VSS.n246 VSS.n245 185
R1328 VSS.n248 VSS.n247 185
R1329 VSS.n1801 VSS.n1800 185
R1330 VSS.n216 VSS.n183 185
R1331 VSS.n218 VSS.n217 185
R1332 VSS.n220 VSS.n219 185
R1333 VSS.n222 VSS.n221 185
R1334 VSS.n224 VSS.n223 185
R1335 VSS.n226 VSS.n225 185
R1336 VSS.n228 VSS.n227 185
R1337 VSS.n230 VSS.n229 185
R1338 VSS.n1803 VSS.n1802 185
R1339 VSS.n176 VSS.n175 185
R1340 VSS.n174 VSS.n173 185
R1341 VSS.n170 VSS.n169 185
R1342 VSS.n1815 VSS.n139 185
R1343 VSS.n1834 VSS.n1833 185
R1344 VSS.n1822 VSS.n138 185
R1345 VSS.n161 VSS.n157 185
R1346 VSS.n1830 VSS.n1829 185
R1347 VSS.n1450 VSS.n1449 185
R1348 VSS.n1451 VSS.n1185 185
R1349 VSS.n1453 VSS.n1452 185
R1350 VSS.n1455 VSS.n1184 185
R1351 VSS.n1458 VSS.n1457 185
R1352 VSS.n1459 VSS.n1183 185
R1353 VSS.n1461 VSS.n1460 185
R1354 VSS.n1463 VSS.n1182 185
R1355 VSS.n1464 VSS.n1170 185
R1356 VSS.n1431 VSS.n1190 185
R1357 VSS.n1434 VSS.n1433 185
R1358 VSS.n1435 VSS.n1189 185
R1359 VSS.n1437 VSS.n1436 185
R1360 VSS.n1439 VSS.n1188 185
R1361 VSS.n1442 VSS.n1441 185
R1362 VSS.n1443 VSS.n1187 185
R1363 VSS.n1445 VSS.n1444 185
R1364 VSS.n1447 VSS.n1186 185
R1365 VSS.n1415 VSS.n1414 185
R1366 VSS.n1417 VSS.n1195 185
R1367 VSS.n1419 VSS.n1418 185
R1368 VSS.n1420 VSS.n1194 185
R1369 VSS.n1422 VSS.n1421 185
R1370 VSS.n1424 VSS.n1192 185
R1371 VSS.n1426 VSS.n1425 185
R1372 VSS.n1427 VSS.n1191 185
R1373 VSS.n1429 VSS.n1428 185
R1374 VSS.n1413 VSS.n1197 185
R1375 VSS.n1411 VSS.n1410 185
R1376 VSS.n1206 VSS.n1198 185
R1377 VSS.n1213 VSS.n1205 185
R1378 VSS.n1216 VSS.n1215 185
R1379 VSS.n1208 VSS.n1181 185
R1380 VSS.n1470 VSS.n1469 185
R1381 VSS.n1467 VSS.n1179 185
R1382 VSS.n1466 VSS.n1172 185
R1383 VSS.n541 VSS.n540 185
R1384 VSS.n543 VSS.n495 185
R1385 VSS.n546 VSS.n545 185
R1386 VSS.n547 VSS.n494 185
R1387 VSS.n549 VSS.n548 185
R1388 VSS.n551 VSS.n493 185
R1389 VSS.n554 VSS.n553 185
R1390 VSS.n555 VSS.n492 185
R1391 VSS.n557 VSS.n556 185
R1392 VSS.n523 VSS.n500 185
R1393 VSS.n525 VSS.n524 185
R1394 VSS.n527 VSS.n526 185
R1395 VSS.n530 VSS.n529 185
R1396 VSS.n531 VSS.n498 185
R1397 VSS.n533 VSS.n532 185
R1398 VSS.n535 VSS.n497 185
R1399 VSS.n538 VSS.n537 185
R1400 VSS.n539 VSS.n496 185
R1401 VSS.n505 VSS.n426 185
R1402 VSS.n509 VSS.n506 185
R1403 VSS.n511 VSS.n510 185
R1404 VSS.n512 VSS.n504 185
R1405 VSS.n514 VSS.n513 185
R1406 VSS.n516 VSS.n502 185
R1407 VSS.n518 VSS.n517 185
R1408 VSS.n519 VSS.n501 185
R1409 VSS.n521 VSS.n520 185
R1410 VSS.n1099 VSS.n1098 185
R1411 VSS.n1096 VSS.n1095 185
R1412 VSS.n428 VSS.n427 185
R1413 VSS.n579 VSS.n578 185
R1414 VSS.n576 VSS.n570 185
R1415 VSS.n569 VSS.n560 185
R1416 VSS.n590 VSS.n589 185
R1417 VSS.n593 VSS.n592 185
R1418 VSS.n559 VSS.n489 185
R1419 VSS.n686 VSS.n685 185
R1420 VSS.n684 VSS.n683 185
R1421 VSS.n682 VSS.n681 185
R1422 VSS.n680 VSS.n679 185
R1423 VSS.n678 VSS.n677 185
R1424 VSS.n676 VSS.n675 185
R1425 VSS.n674 VSS.n673 185
R1426 VSS.n644 VSS.n643 185
R1427 VSS.n756 VSS.n755 185
R1428 VSS.n704 VSS.n703 185
R1429 VSS.n702 VSS.n701 185
R1430 VSS.n700 VSS.n699 185
R1431 VSS.n698 VSS.n697 185
R1432 VSS.n696 VSS.n695 185
R1433 VSS.n694 VSS.n693 185
R1434 VSS.n692 VSS.n691 185
R1435 VSS.n690 VSS.n689 185
R1436 VSS.n688 VSS.n687 185
R1437 VSS.n723 VSS.n722 185
R1438 VSS.n720 VSS.n719 185
R1439 VSS.n718 VSS.n717 185
R1440 VSS.n716 VSS.n715 185
R1441 VSS.n714 VSS.n713 185
R1442 VSS.n712 VSS.n711 185
R1443 VSS.n710 VSS.n709 185
R1444 VSS.n708 VSS.n707 185
R1445 VSS.n706 VSS.n705 185
R1446 VSS.n721 VSS.n668 185
R1447 VSS.n667 VSS.n666 185
R1448 VSS.n665 VSS.n664 185
R1449 VSS.n739 VSS.n738 185
R1450 VSS.n737 VSS.n653 185
R1451 VSS.n652 VSS.n651 185
R1452 VSS.n648 VSS.n626 185
R1453 VSS.n760 VSS.n759 185
R1454 VSS.n625 VSS.n624 185
R1455 VSS.n1257 VSS.t32 185
R1456 VSS.t32 VSS.n1238 185
R1457 VSS.n1310 VSS.n1309 185
R1458 VSS.n2011 VSS.n11 185
R1459 VSS.n2011 VSS.t33 185
R1460 VSS.n1849 VSS.n15 185
R1461 VSS.n2013 VSS.n2012 185
R1462 VSS.n59 VSS.n13 185
R1463 VSS.n61 VSS.n60 185
R1464 VSS.n63 VSS.n62 185
R1465 VSS.n65 VSS.n64 185
R1466 VSS.n67 VSS.n66 185
R1467 VSS.n69 VSS.n68 185
R1468 VSS.n71 VSS.n70 185
R1469 VSS.n73 VSS.n72 185
R1470 VSS.n75 VSS.n74 185
R1471 VSS.n77 VSS.n76 185
R1472 VSS.n79 VSS.n78 185
R1473 VSS.n81 VSS.n80 185
R1474 VSS.n83 VSS.n82 185
R1475 VSS.n85 VSS.n84 185
R1476 VSS.n87 VSS.n86 185
R1477 VSS.n88 VSS.n31 185
R1478 VSS.t33 VSS.n31 185
R1479 VSS.n90 VSS.n89 185
R1480 VSS.n92 VSS.n91 185
R1481 VSS.n94 VSS.n93 185
R1482 VSS.n96 VSS.n95 185
R1483 VSS.n98 VSS.n97 185
R1484 VSS.n100 VSS.n99 185
R1485 VSS.n102 VSS.n101 185
R1486 VSS.n104 VSS.n103 185
R1487 VSS.n106 VSS.n105 185
R1488 VSS.n107 VSS.n33 185
R1489 VSS.n1854 VSS.n1853 185
R1490 VSS.n1852 VSS.n1842 185
R1491 VSS.n1862 VSS.n1861 185
R1492 VSS.n1864 VSS.n1863 185
R1493 VSS.n1839 VSS.n1838 185
R1494 VSS.n35 VSS.n32 185
R1495 VSS.n2009 VSS.n2008 185
R1496 VSS.n1902 VSS.n54 185
R1497 VSS.n1979 VSS.n1978 185
R1498 VSS.n1982 VSS.n1981 185
R1499 VSS.n51 VSS.n45 185
R1500 VSS.n1995 VSS.n1994 185
R1501 VSS.n1992 VSS.n1991 185
R1502 VSS.n47 VSS.n46 185
R1503 VSS.n1957 VSS.n1956 185
R1504 VSS.n1954 VSS.n1884 185
R1505 VSS.n116 VSS.n40 184.113
R1506 VSS.n1857 VSS.t37 180.03
R1507 VSS.n1707 VSS.n1706 175.546
R1508 VSS.n1714 VSS.n1713 175.546
R1509 VSS.n1721 VSS.n1720 175.546
R1510 VSS.n1733 VSS.n272 175.546
R1511 VSS.n271 VSS.n266 175.546
R1512 VSS.n1696 VSS.n281 175.546
R1513 VSS.n790 VSS.n789 175.546
R1514 VSS.n832 VSS.n831 175.546
R1515 VSS.n829 VSS.n793 175.546
R1516 VSS.n819 VSS.n818 175.546
R1517 VSS.n1488 VSS.n311 175.546
R1518 VSS.n1496 VSS.n1486 175.546
R1519 VSS.n1500 VSS.n1498 175.546
R1520 VSS.n1508 VSS.n1484 175.546
R1521 VSS.n1512 VSS.n1510 175.546
R1522 VSS.n1796 VSS.n188 175.546
R1523 VSS.n1742 VSS.n1741 175.546
R1524 VSS.n1827 VSS.n1826 175.546
R1525 VSS.n1824 VSS.n163 175.546
R1526 VSS.n1813 VSS.n1812 175.546
R1527 VSS.n1810 VSS.n172 175.546
R1528 VSS.n1797 VSS.n187 175.546
R1529 VSS.n1114 VSS.n385 175.546
R1530 VSS.n1110 VSS.n385 175.546
R1531 VSS.n1110 VSS.n1107 175.546
R1532 VSS.n1107 VSS.n1106 175.546
R1533 VSS.n1106 VSS.n388 175.546
R1534 VSS.n394 VSS.n388 175.546
R1535 VSS.n395 VSS.n394 175.546
R1536 VSS.n398 VSS.n395 175.546
R1537 VSS.n398 VSS.n391 175.546
R1538 VSS.n402 VSS.n391 175.546
R1539 VSS.n402 VSS.n376 175.546
R1540 VSS.n408 VSS.n407 175.546
R1541 VSS.n1613 VSS.n1612 175.546
R1542 VSS.n1610 VSS.n324 175.546
R1543 VSS.n362 VSS.n361 175.546
R1544 VSS.n374 VSS.n373 175.546
R1545 VSS.n1545 VSS.n1544 175.546
R1546 VSS.n986 VSS.n985 175.546
R1547 VSS.n985 VSS.n952 175.546
R1548 VSS.n981 VSS.n952 175.546
R1549 VSS.n981 VSS.n956 175.546
R1550 VSS.n977 VSS.n956 175.546
R1551 VSS.n977 VSS.n976 175.546
R1552 VSS.n976 VSS.n975 175.546
R1553 VSS.n975 VSS.n961 175.546
R1554 VSS.n971 VSS.n961 175.546
R1555 VSS.n971 VSS.n970 175.546
R1556 VSS.n1027 VSS.n948 175.546
R1557 VSS.n1023 VSS.n948 175.546
R1558 VSS.n1023 VSS.n994 175.546
R1559 VSS.n1019 VSS.n994 175.546
R1560 VSS.n1019 VSS.n996 175.546
R1561 VSS.n1015 VSS.n996 175.546
R1562 VSS.n1015 VSS.n999 175.546
R1563 VSS.n1011 VSS.n999 175.546
R1564 VSS.n1011 VSS.n1001 175.546
R1565 VSS.n1007 VSS.n1001 175.546
R1566 VSS.n1007 VSS.n1004 175.546
R1567 VSS.n988 VSS.n950 175.546
R1568 VSS.n953 VSS.n950 175.546
R1569 VSS.n954 VSS.n953 175.546
R1570 VSS.n958 VSS.n954 175.546
R1571 VSS.n959 VSS.n958 175.546
R1572 VSS.n963 VSS.n959 175.546
R1573 VSS.n964 VSS.n963 175.546
R1574 VSS.n966 VSS.n964 175.546
R1575 VSS.n967 VSS.n966 175.546
R1576 VSS.n968 VSS.n967 175.546
R1577 VSS.n1693 VSS.n1692 175.546
R1578 VSS.n1690 VSS.n288 175.546
R1579 VSS.n799 VSS.n797 175.546
R1580 VSS.n826 VSS.n825 175.546
R1581 VSS.n823 VSS.n806 175.546
R1582 VSS.n1054 VSS.n453 175.546
R1583 VSS.n1060 VSS.n453 175.546
R1584 VSS.n1060 VSS.n448 175.546
R1585 VSS.n1066 VSS.n448 175.546
R1586 VSS.n1067 VSS.n1066 175.546
R1587 VSS.n1068 VSS.n1067 175.546
R1588 VSS.n1068 VSS.n445 175.546
R1589 VSS.n1074 VSS.n445 175.546
R1590 VSS.n1074 VSS.n440 175.546
R1591 VSS.n1081 VSS.n440 175.546
R1592 VSS.n1082 VSS.n1081 175.546
R1593 VSS.n1052 VSS.n458 175.546
R1594 VSS.n1048 VSS.n458 175.546
R1595 VSS.n1048 VSS.n935 175.546
R1596 VSS.n1044 VSS.n935 175.546
R1597 VSS.n1044 VSS.n938 175.546
R1598 VSS.n1040 VSS.n938 175.546
R1599 VSS.n1040 VSS.n940 175.546
R1600 VSS.n1036 VSS.n940 175.546
R1601 VSS.n1036 VSS.n942 175.546
R1602 VSS.n1032 VSS.n942 175.546
R1603 VSS.n1032 VSS.n944 175.546
R1604 VSS.n1491 VSS.n1490 175.546
R1605 VSS.n1494 VSS.n1493 175.546
R1606 VSS.n1503 VSS.n1502 175.546
R1607 VSS.n1506 VSS.n1505 175.546
R1608 VSS.n1515 VSS.n1482 175.546
R1609 VSS.n1618 VSS.n1617 175.546
R1610 VSS.n1615 VSS.n319 175.546
R1611 VSS.n353 VSS.n327 175.546
R1612 VSS.n364 VSS.n355 175.546
R1613 VSS.n368 VSS.n367 175.546
R1614 VSS.n1146 VSS.n350 175.546
R1615 VSS.n1151 VSS.n1149 175.546
R1616 VSS.n1151 VSS.n1144 175.546
R1617 VSS.n1155 VSS.n1144 175.546
R1618 VSS.n1155 VSS.n1142 175.546
R1619 VSS.n1519 VSS.n1142 175.546
R1620 VSS.n1520 VSS.n1519 175.546
R1621 VSS.n1523 VSS.n1520 175.546
R1622 VSS.n1523 VSS.n1140 175.546
R1623 VSS.n1527 VSS.n1140 175.546
R1624 VSS.n1527 VSS.n1137 175.546
R1625 VSS.n1531 VSS.n1137 175.546
R1626 VSS.n1476 VSS.n1167 175.546
R1627 VSS.n1476 VSS.n1173 175.546
R1628 VSS.n1472 VSS.n1173 175.546
R1629 VSS.n1472 VSS.n1177 175.546
R1630 VSS.n1207 VSS.n1177 175.546
R1631 VSS.n1218 VSS.n1207 175.546
R1632 VSS.n1219 VSS.n1218 175.546
R1633 VSS.n1219 VSS.n1201 175.546
R1634 VSS.n1408 VSS.n1201 175.546
R1635 VSS.n1408 VSS.n1202 175.546
R1636 VSS.n1202 VSS.n1138 175.546
R1637 VSS.n1399 VSS.n1226 175.546
R1638 VSS.n1397 VSS.n1396 175.546
R1639 VSS.n1394 VSS.n1393 175.546
R1640 VSS.n1391 VSS.n1229 175.546
R1641 VSS.n1387 VSS.n1386 175.546
R1642 VSS.n1384 VSS.n1132 175.546
R1643 VSS.n1372 VSS.n1371 175.546
R1644 VSS.n1368 VSS.n1367 175.546
R1645 VSS.n1364 VSS.n1363 175.546
R1646 VSS.n1360 VSS.n1359 175.546
R1647 VSS.n1356 VSS.n1131 175.546
R1648 VSS.n1331 VSS.n1330 175.546
R1649 VSS.n1337 VSS.n1336 175.546
R1650 VSS.n1345 VSS.n1344 175.546
R1651 VSS.n1353 VSS.n1321 175.546
R1652 VSS.n1320 VSS.n1312 175.546
R1653 VSS.n1171 VSS.n1169 175.546
R1654 VSS.n1174 VSS.n1171 175.546
R1655 VSS.n1175 VSS.n1174 175.546
R1656 VSS.n1209 VSS.n1175 175.546
R1657 VSS.n1210 VSS.n1209 175.546
R1658 VSS.n1210 VSS.n1204 175.546
R1659 VSS.n1221 VSS.n1204 175.546
R1660 VSS.n1222 VSS.n1221 175.546
R1661 VSS.n1222 VSS.n1200 175.546
R1662 VSS.n1225 VSS.n1200 175.546
R1663 VSS.n1404 VSS.n1225 175.546
R1664 VSS.n898 VSS.n896 175.546
R1665 VSS.n894 VSS.n473 175.546
R1666 VSS.n890 VSS.n473 175.546
R1667 VSS.n890 VSS.n475 175.546
R1668 VSS.n886 VSS.n475 175.546
R1669 VSS.n886 VSS.n478 175.546
R1670 VSS.n882 VSS.n478 175.546
R1671 VSS.n882 VSS.n480 175.546
R1672 VSS.n878 VSS.n480 175.546
R1673 VSS.n906 VSS.n904 175.546
R1674 VSS.n906 VSS.n468 175.546
R1675 VSS.n911 VSS.n468 175.546
R1676 VSS.n911 VSS.n466 175.546
R1677 VSS.n916 VSS.n466 175.546
R1678 VSS.n916 VSS.n464 175.546
R1679 VSS.n920 VSS.n464 175.546
R1680 VSS.n920 VSS.n463 175.546
R1681 VSS.n924 VSS.n463 175.546
R1682 VSS.n924 VSS.n461 175.546
R1683 VSS.n929 VSS.n461 175.546
R1684 VSS.n1057 VSS.n1056 175.546
R1685 VSS.n1057 VSS.n451 175.546
R1686 VSS.n1063 VSS.n451 175.546
R1687 VSS.n1064 VSS.n1063 175.546
R1688 VSS.n1064 VSS.n446 175.546
R1689 VSS.n1070 VSS.n446 175.546
R1690 VSS.n1071 VSS.n1070 175.546
R1691 VSS.n1071 VSS.n443 175.546
R1692 VSS.n1077 VSS.n443 175.546
R1693 VSS.n1079 VSS.n1077 175.546
R1694 VSS.n1079 VSS.n1078 175.546
R1695 VSS.n596 VSS.n595 175.546
R1696 VSS.n563 VSS.n562 175.546
R1697 VSS.n582 VSS.n581 175.546
R1698 VSS.n572 VSS.n422 175.546
R1699 VSS.n1101 VSS.n423 175.546
R1700 VSS.n872 VSS.n871 175.546
R1701 VSS.n871 VSS.n604 175.546
R1702 VSS.n867 VSS.n604 175.546
R1703 VSS.n867 VSS.n606 175.546
R1704 VSS.n863 VSS.n606 175.546
R1705 VSS.n863 VSS.n862 175.546
R1706 VSS.n862 VSS.n861 175.546
R1707 VSS.n861 VSS.n610 175.546
R1708 VSS.n780 VSS.n610 175.546
R1709 VSS.n780 VSS.n613 175.546
R1710 VSS.n776 VSS.n613 175.546
R1711 VSS.n599 VSS.n487 175.546
R1712 VSS.n587 VSS.n566 175.546
R1713 VSS.n585 VSS.n568 175.546
R1714 VSS.n1092 VSS.n429 175.546
R1715 VSS.n1090 VSS.n1089 175.546
R1716 VSS.n1703 VSS.n1702 175.546
R1717 VSS.n1710 VSS.n1709 175.546
R1718 VSS.n1717 VSS.n1716 175.546
R1719 VSS.n1725 VSS.n1724 175.546
R1720 VSS.n1730 VSS.n206 175.546
R1721 VSS.n752 VSS.n751 175.546
R1722 VSS.n749 VSS.n748 175.546
R1723 VSS.n746 VSS.n650 175.546
R1724 VSS.n735 VSS.n734 175.546
R1725 VSS.n732 VSS.n663 175.546
R1726 VSS.n765 VSS.n764 175.546
R1727 VSS.n762 VSS.n621 175.546
R1728 VSS.n743 VSS.n656 175.546
R1729 VSS.n741 VSS.n657 175.546
R1730 VSS.n729 VSS.n671 175.546
R1731 VSS.n727 VSS.n210 175.546
R1732 VSS.n770 VSS.n769 175.546
R1733 VSS.n769 VSS.n133 175.546
R1734 VSS.n1869 VSS.n133 175.546
R1735 VSS.n1869 VSS.n131 175.546
R1736 VSS.n1873 VSS.n131 175.546
R1737 VSS.n1873 VSS.n129 175.546
R1738 VSS.n1877 VSS.n129 175.546
R1739 VSS.n1877 VSS.n127 175.546
R1740 VSS.n1881 VSS.n127 175.546
R1741 VSS.n1881 VSS.n124 175.546
R1742 VSS.n1965 VSS.n124 175.546
R1743 VSS.n1961 VSS.n1960 175.546
R1744 VSS.n1989 VSS.n48 175.546
R1745 VSS.n1987 VSS.n1986 175.546
R1746 VSS.n1984 VSS.n50 175.546
R1747 VSS.n1976 VSS.n1975 175.546
R1748 VSS.n1786 VSS.n211 175.546
R1749 VSS.n1752 VSS.n211 175.546
R1750 VSS.n1753 VSS.n1752 175.546
R1751 VSS.n1776 VSS.n1753 175.546
R1752 VSS.n1776 VSS.n1775 175.546
R1753 VSS.n1775 VSS.n1757 175.546
R1754 VSS.n1761 VSS.n1757 175.546
R1755 VSS.n1762 VSS.n1761 175.546
R1756 VSS.n1764 VSS.n1762 175.546
R1757 VSS.n1764 VSS.n1763 175.546
R1758 VSS.n1763 VSS.n57 175.546
R1759 VSS.n1747 VSS.n1746 175.546
R1760 VSS.n1820 VSS.n1819 175.546
R1761 VSS.n1817 VSS.n166 175.546
R1762 VSS.n1807 VSS.n179 175.546
R1763 VSS.n1805 VSS.n180 175.546
R1764 VSS.n1784 VSS.n1783 175.546
R1765 VSS.n1783 VSS.n1751 175.546
R1766 VSS.n1779 VSS.n1751 175.546
R1767 VSS.n1779 VSS.n1755 175.546
R1768 VSS.n1773 VSS.n1755 175.546
R1769 VSS.n1773 VSS.n1772 175.546
R1770 VSS.n1772 VSS.n1771 175.546
R1771 VSS.n1771 VSS.n1759 175.546
R1772 VSS.n1767 VSS.n1759 175.546
R1773 VSS.n1767 VSS.n110 175.546
R1774 VSS.n1968 VSS.n110 175.546
R1775 VSS.n2016 VSS.n9 172.137
R1776 VSS.n2016 VSS.n10 172.137
R1777 VSS.t13 VSS.n7 171.457
R1778 VSS.n843 VSS.n842 167.576
R1779 VSS.n1009 VSS.t0 167.392
R1780 VSS.n116 VSS.n36 165.702
R1781 VSS.n2006 VSS.n36 165.702
R1782 VSS.n2006 VSS.n37 165.702
R1783 VSS.n1844 VSS.n37 165.702
R1784 VSS.n1845 VSS.n1844 165.702
R1785 VSS.n1859 VSS.n1845 165.702
R1786 VSS.n1859 VSS.n1858 165.702
R1787 VSS.n1858 VSS.n1847 165.702
R1788 VSS.n1937 VSS.n1935 163.333
R1789 VSS.n1292 VSS.n1290 163.333
R1790 VSS.n1585 VSS.n1584 163.333
R1791 VSS.n1665 VSS.n296 163.333
R1792 VSS.n249 VSS.n248 163.333
R1793 VSS.n1449 VSS.n1447 163.333
R1794 VSS.n541 VSS.n496 163.333
R1795 VSS.n687 VSS.n686 163.333
R1796 VSS.n1846 VSS.n9 160.143
R1797 VSS.n856 VSS.n855 155.239
R1798 VSS.n921 VSS.t5 153.043
R1799 VSS.t18 VSS.n2004 150.024
R1800 VSS.n1933 VSS.n1892 150
R1801 VSS.n1929 VSS.n1927 150
R1802 VSS.n1925 VSS.n1894 150
R1803 VSS.n1921 VSS.n1919 150
R1804 VSS.n1917 VSS.n1896 150
R1805 VSS.n1913 VSS.n1912 150
R1806 VSS.n1910 VSS.n1899 150
R1807 VSS.n1906 VSS.n1905 150
R1808 VSS.n1956 VSS.n1954 150
R1809 VSS.n1992 VSS.n46 150
R1810 VSS.n1994 VSS.n45 150
R1811 VSS.n1981 VSS.n1979 150
R1812 VSS.n1941 VSS.n1890 150
R1813 VSS.n1945 VSS.n1943 150
R1814 VSS.n1949 VSS.n1888 150
R1815 VSS.n1952 VSS.n1951 150
R1816 VSS.n93 VSS.n92 150
R1817 VSS.n97 VSS.n96 150
R1818 VSS.n101 VSS.n100 150
R1819 VSS.n105 VSS.n104 150
R1820 VSS.n89 VSS.n31 150
R1821 VSS.n86 VSS.n31 150
R1822 VSS.n84 VSS.n83 150
R1823 VSS.n80 VSS.n79 150
R1824 VSS.n76 VSS.n75 150
R1825 VSS.n72 VSS.n71 150
R1826 VSS.n68 VSS.n67 150
R1827 VSS.n64 VSS.n63 150
R1828 VSS.n60 VSS.n59 150
R1829 VSS.n1838 VSS.n32 150
R1830 VSS.n1863 VSS.n1862 150
R1831 VSS.n1853 VSS.n1852 150
R1832 VSS.n2011 VSS.n15 150
R1833 VSS.n1296 VSS.n1245 150
R1834 VSS.n1300 VSS.n1298 150
R1835 VSS.n1304 VSS.n1243 150
R1836 VSS.n1307 VSS.n1306 150
R1837 VSS.n1288 VSS.n1247 150
R1838 VSS.n1284 VSS.n1282 150
R1839 VSS.n1280 VSS.n1249 150
R1840 VSS.n1276 VSS.n1274 150
R1841 VSS.n1272 VSS.n1251 150
R1842 VSS.n1268 VSS.n1267 150
R1843 VSS.n1265 VSS.n1254 150
R1844 VSS.n1261 VSS.n1260 150
R1845 VSS.n1309 VSS.n1238 150
R1846 VSS.n1581 VSS.n1580 150
R1847 VSS.n1577 VSS.n1576 150
R1848 VSS.n1573 VSS.n1572 150
R1849 VSS.n1569 VSS.n1568 150
R1850 VSS.n1565 VSS.n1564 150
R1851 VSS.n1561 VSS.n1560 150
R1852 VSS.n1557 VSS.n1556 150
R1853 VSS.n1553 VSS.n1552 150
R1854 VSS.n1604 VSS.n1603 150
R1855 VSS.n1607 VSS.n329 150
R1856 VSS.n356 VSS.n330 150
R1857 VSS.n370 VSS.n369 150
R1858 VSS.n1589 VSS.n1588 150
R1859 VSS.n1593 VSS.n1592 150
R1860 VSS.n1597 VSS.n1596 150
R1861 VSS.n1602 VSS.n347 150
R1862 VSS.n1661 VSS.n1659 150
R1863 VSS.n1657 VSS.n298 150
R1864 VSS.n1653 VSS.n1651 150
R1865 VSS.n1648 VSS.n1647 150
R1866 VSS.n1645 VSS.n301 150
R1867 VSS.n1641 VSS.n1640 150
R1868 VSS.n1638 VSS.n304 150
R1869 VSS.n1634 VSS.n1633 150
R1870 VSS.n1685 VSS.n1683 150
R1871 VSS.n1687 VSS.n291 150
R1872 VSS.n810 VSS.n809 150
R1873 VSS.n814 VSS.n812 150
R1874 VSS.n1669 VSS.n1667 150
R1875 VSS.n1673 VSS.n294 150
R1876 VSS.n1677 VSS.n1675 150
R1877 VSS.n1681 VSS.n292 150
R1878 VSS.n245 VSS.n244 150
R1879 VSS.n241 VSS.n240 150
R1880 VSS.n237 VSS.n236 150
R1881 VSS.n233 VSS.n232 150
R1882 VSS.n229 VSS.n228 150
R1883 VSS.n225 VSS.n224 150
R1884 VSS.n221 VSS.n220 150
R1885 VSS.n217 VSS.n216 150
R1886 VSS.n1830 VSS.n157 150
R1887 VSS.n1833 VSS.n138 150
R1888 VSS.n169 VSS.n139 150
R1889 VSS.n175 VSS.n174 150
R1890 VSS.n253 VSS.n252 150
R1891 VSS.n257 VSS.n256 150
R1892 VSS.n261 VSS.n260 150
R1893 VSS.n263 VSS.n156 150
R1894 VSS.n1445 VSS.n1187 150
R1895 VSS.n1441 VSS.n1439 150
R1896 VSS.n1437 VSS.n1189 150
R1897 VSS.n1433 VSS.n1431 150
R1898 VSS.n1429 VSS.n1191 150
R1899 VSS.n1425 VSS.n1424 150
R1900 VSS.n1422 VSS.n1194 150
R1901 VSS.n1418 VSS.n1417 150
R1902 VSS.n1467 VSS.n1466 150
R1903 VSS.n1469 VSS.n1181 150
R1904 VSS.n1215 VSS.n1213 150
R1905 VSS.n1411 VSS.n1198 150
R1906 VSS.n1453 VSS.n1185 150
R1907 VSS.n1457 VSS.n1455 150
R1908 VSS.n1461 VSS.n1183 150
R1909 VSS.n1464 VSS.n1463 150
R1910 VSS.n537 VSS.n535 150
R1911 VSS.n533 VSS.n498 150
R1912 VSS.n529 VSS.n527 150
R1913 VSS.n524 VSS.n523 150
R1914 VSS.n521 VSS.n501 150
R1915 VSS.n517 VSS.n516 150
R1916 VSS.n514 VSS.n504 150
R1917 VSS.n510 VSS.n509 150
R1918 VSS.n592 VSS.n559 150
R1919 VSS.n590 VSS.n560 150
R1920 VSS.n578 VSS.n576 150
R1921 VSS.n1096 VSS.n427 150
R1922 VSS.n545 VSS.n543 150
R1923 VSS.n549 VSS.n494 150
R1924 VSS.n553 VSS.n551 150
R1925 VSS.n557 VSS.n492 150
R1926 VSS.n691 VSS.n690 150
R1927 VSS.n695 VSS.n694 150
R1928 VSS.n699 VSS.n698 150
R1929 VSS.n703 VSS.n702 150
R1930 VSS.n707 VSS.n706 150
R1931 VSS.n711 VSS.n710 150
R1932 VSS.n715 VSS.n714 150
R1933 VSS.n719 VSS.n718 150
R1934 VSS.n759 VSS.n625 150
R1935 VSS.n651 VSS.n626 150
R1936 VSS.n738 VSS.n737 150
R1937 VSS.n666 VSS.n665 150
R1938 VSS.n683 VSS.n682 150
R1939 VSS.n679 VSS.n678 150
R1940 VSS.n675 VSS.n674 150
R1941 VSS.n756 VSS.n643 150
R1942 VSS.t2 VSS.n943 148.262
R1943 VSS.n1347 VSS.n1323 146.549
R1944 VSS.n117 VSS.t38 141.452
R1945 VSS.n1843 VSS.t22 141.452
R1946 VSS.n855 VSS.n784 139.446
R1947 VSS.t3 VSS.n1042 133.913
R1948 VSS.t31 VSS.n1 73.2037
R1949 VSS.n416 VSS.t31 133.431
R1950 VSS.n901 VSS.n415 131.19
R1951 VSS.n646 VSS.n1 169.061
R1952 VSS.n1626 VSS.n311 126.782
R1953 VSS.n1114 VSS.n384 126.782
R1954 VSS.n989 VSS.n988 126.782
R1955 VSS.n1149 VSS.n1148 126.782
R1956 VSS.n1403 VSS.n1226 126.782
R1957 VSS.n1056 VSS.n455 126.782
R1958 VSS.n435 VSS.n431 126.782
R1959 VSS.n1787 VSS.n1786 126.782
R1960 VSS.n1700 VSS.n1699 124.832
R1961 VSS.n986 VSS.n947 124.832
R1962 VSS.n1054 VSS.n1053 124.832
R1963 VSS.n1619 VSS.n317 124.832
R1964 VSS.n1327 VSS.n1326 124.832
R1965 VSS.n903 VSS.n470 124.832
R1966 VSS.n872 VSS.n485 124.832
R1967 VSS.n770 VSS.n618 124.832
R1968 VSS.n1784 VSS.n1750 124.832
R1969 VSS.n430 VSS.n416 124.081
R1970 VSS.n849 VSS.n785 121.743
R1971 VSS.n858 VSS.t19 119.876
R1972 VSS.n1843 VSS.t23 115.734
R1973 VSS.n997 VSS.t1 114.784
R1974 VSS.t25 VSS.n914 112.391
R1975 VSS.t25 VSS.n1041 112.391
R1976 VSS.t25 VSS.n1016 112.391
R1977 VSS.n840 VSS.t9 109.939
R1978 VSS.n192 VSS.n191 109.228
R1979 VSS.n2001 VSS.n2000 108.8
R1980 VSS.n1241 VSS.n1237 106.733
R1981 VSS.n1240 VSS.n1236 106.733
R1982 VSS.n1239 VSS.n1235 106.733
R1983 VSS.n1239 VSS.n1234 106.733
R1984 VSS.n1240 VSS.n1235 106.733
R1985 VSS.n1241 VSS.n1236 106.733
R1986 VSS.n915 VSS.t25 102.826
R1987 VSS.n1042 VSS.t25 102.826
R1988 VSS.n1017 VSS.t25 102.826
R1989 VSS.t34 VSS.n115 100.731
R1990 VSS.n1362 VSS.t34 100.731
R1991 VSS.n1024 VSS.t1 100.436
R1992 VSS.n840 VSS.t21 98.1372
R1993 VSS.n2002 VSS.n3 94.3383
R1994 VSS.n901 VSS.n900 92.2437
R1995 VSS.n900 VSS.n899 92.2437
R1996 VSS.n899 VSS.n472 92.2437
R1997 VSS.n893 VSS.n472 92.2437
R1998 VSS.n893 VSS.n892 92.2437
R1999 VSS.n892 VSS.n891 92.2437
R2000 VSS.n891 VSS.n474 92.2437
R2001 VSS.n885 VSS.n474 92.2437
R2002 VSS.n885 VSS.n884 92.2437
R2003 VSS.n884 VSS.n883 92.2437
R2004 VSS.n883 VSS.n479 92.2437
R2005 VSS.n877 VSS.n479 92.2437
R2006 VSS.n876 VSS.n484 92.2437
R2007 VSS.n870 VSS.n484 92.2437
R2008 VSS.n870 VSS.n869 92.2437
R2009 VSS.n869 VSS.n868 92.2437
R2010 VSS.n868 VSS.n605 92.2437
R2011 VSS.n605 VSS.n199 92.2437
R2012 VSS.n860 VSS.n200 92.2437
R2013 VSS.n782 VSS.n781 92.2437
R2014 VSS.n781 VSS.n612 92.2437
R2015 VSS.n775 VSS.n612 92.2437
R2016 VSS.n774 VSS.n617 92.2437
R2017 VSS.n768 VSS.n617 92.2437
R2018 VSS.n768 VSS.n132 92.2437
R2019 VSS.n1870 VSS.n132 92.2437
R2020 VSS.n1871 VSS.n1870 92.2437
R2021 VSS.n1872 VSS.n1871 92.2437
R2022 VSS.n1872 VSS.n128 92.2437
R2023 VSS.n1878 VSS.n128 92.2437
R2024 VSS.n1879 VSS.n1878 92.2437
R2025 VSS.n1880 VSS.n1879 92.2437
R2026 VSS.n1880 VSS.n123 92.2437
R2027 VSS.n1966 VSS.n123 92.2437
R2028 VSS.t34 VSS.n114 92.1583
R2029 VSS.n1365 VSS.t34 92.1583
R2030 VSS.n10 VSS.n6 91.8063
R2031 VSS.n1333 VSS.n1332 91.248
R2032 VSS.n1339 VSS.n1325 91.248
R2033 VSS.n1342 VSS.n1341 91.248
R2034 VSS.n1349 VSS.n1348 91.248
R2035 VSS.n1350 VSS.n1313 91.248
R2036 VSS.n1379 VSS.n1378 91.248
R2037 VSS.n1380 VSS.n1379 91.248
R2038 VSS.n1351 VSS.n1350 91.248
R2039 VSS.n1348 VSS.n1347 91.248
R2040 VSS.n1341 VSS.n1340 91.248
R2041 VSS.n1334 VSS.n1325 91.248
R2042 VSS.n1332 VSS.n193 91.248
R2043 VSS.n2003 VSS.n2002 83.5719
R2044 VSS.n2004 VSS.n2003 83.5719
R2045 VSS.n1043 VSS.t3 81.3049
R2046 VSS.n990 VSS.t2 81.3049
R2047 VSS.n165 VSS.t34 209.756
R2048 VSS.n859 VSS.n782 77.8947
R2049 VSS.t23 VSS.n39 77.1559
R2050 VSS.n1700 VSS.n267 76.3222
R2051 VSS.n1707 VSS.n268 76.3222
R2052 VSS.n1714 VSS.n269 76.3222
R2053 VSS.n1721 VSS.n270 76.3222
R2054 VSS.n1734 VSS.n1733 76.3222
R2055 VSS.n1740 VSS.n1736 76.3222
R2056 VSS.n1697 VSS.n1696 76.3222
R2057 VSS.n789 VSS.n788 76.3222
R2058 VSS.n832 VSS.n791 76.3222
R2059 VSS.n830 VSS.n829 76.3222
R2060 VSS.n818 VSS.n817 76.3222
R2061 VSS.n1627 VSS.n310 76.3222
R2062 VSS.n1487 VSS.n1486 76.3222
R2063 VSS.n1498 VSS.n1497 76.3222
R2064 VSS.n1499 VSS.n1484 76.3222
R2065 VSS.n1510 VSS.n1509 76.3222
R2066 VSS.n1511 VSS.n188 76.3222
R2067 VSS.n1827 VSS.n160 76.3222
R2068 VSS.n1825 VSS.n1824 76.3222
R2069 VSS.n1813 VSS.n168 76.3222
R2070 VSS.n1811 VSS.n1810 76.3222
R2071 VSS.n187 VSS.n186 76.3222
R2072 VSS.n1613 VSS.n322 76.3222
R2073 VSS.n1611 VSS.n1610 76.3222
R2074 VSS.n361 VSS.n358 76.3222
R2075 VSS.n373 VSS.n351 76.3222
R2076 VSS.n1545 VSS.n375 76.3222
R2077 VSS.n970 VSS.n316 76.3222
R2078 VSS.n803 VSS.n312 76.3222
R2079 VSS.n1693 VSS.n284 76.3222
R2080 VSS.n1691 VSS.n1690 76.3222
R2081 VSS.n797 VSS.n796 76.3222
R2082 VSS.n826 VSS.n800 76.3222
R2083 VSS.n824 VSS.n823 76.3222
R2084 VSS.n805 VSS.n804 76.3222
R2085 VSS.n968 VSS.n312 76.3222
R2086 VSS.n409 VSS.n316 76.3222
R2087 VSS.n186 VSS.n172 76.3222
R2088 VSS.n1812 VSS.n1811 76.3222
R2089 VSS.n168 VSS.n163 76.3222
R2090 VSS.n1826 VSS.n1825 76.3222
R2091 VSS.n1742 VSS.n160 76.3222
R2092 VSS.n1162 VSS.n317 76.3222
R2093 VSS.n1491 VSS.n1163 76.3222
R2094 VSS.n1493 VSS.n1164 76.3222
R2095 VSS.n1503 VSS.n1165 76.3222
R2096 VSS.n1505 VSS.n1166 76.3222
R2097 VSS.n1516 VSS.n1515 76.3222
R2098 VSS.n1616 VSS.n1615 76.3222
R2099 VSS.n327 VSS.n326 76.3222
R2100 VSS.n355 VSS.n354 76.3222
R2101 VSS.n368 VSS.n365 76.3222
R2102 VSS.n366 VSS.n350 76.3222
R2103 VSS.n1398 VSS.n1397 76.3222
R2104 VSS.n1395 VSS.n1394 76.3222
R2105 VSS.n1392 VSS.n1391 76.3222
R2106 VSS.n1387 VSS.n1231 76.3222
R2107 VSS.n1385 VSS.n1384 76.3222
R2108 VSS.n1372 VSS.n1126 76.3222
R2109 VSS.n1368 VSS.n1127 76.3222
R2110 VSS.n1364 VSS.n1128 76.3222
R2111 VSS.n1360 VSS.n1129 76.3222
R2112 VSS.n1356 VSS.n1130 76.3222
R2113 VSS.n1536 VSS.n1535 76.3222
R2114 VSS.n1327 VSS.n1316 76.3222
R2115 VSS.n1331 VSS.n1317 76.3222
R2116 VSS.n1336 VSS.n1318 76.3222
R2117 VSS.n1345 VSS.n1319 76.3222
R2118 VSS.n1354 VSS.n1353 76.3222
R2119 VSS.n1376 VSS.n1315 76.3222
R2120 VSS.n1512 VSS.n1511 76.3222
R2121 VSS.n1509 VSS.n1508 76.3222
R2122 VSS.n1500 VSS.n1499 76.3222
R2123 VSS.n1497 VSS.n1496 76.3222
R2124 VSS.n1488 VSS.n1487 76.3222
R2125 VSS.n1490 VSS.n1162 76.3222
R2126 VSS.n1494 VSS.n1163 76.3222
R2127 VSS.n1502 VSS.n1164 76.3222
R2128 VSS.n1506 VSS.n1165 76.3222
R2129 VSS.n1482 VSS.n1166 76.3222
R2130 VSS.n819 VSS.n310 76.3222
R2131 VSS.n817 VSS.n793 76.3222
R2132 VSS.n831 VSS.n830 76.3222
R2133 VSS.n791 VSS.n790 76.3222
R2134 VSS.n788 VSS.n281 76.3222
R2135 VSS.n367 VSS.n366 76.3222
R2136 VSS.n365 VSS.n364 76.3222
R2137 VSS.n354 VSS.n353 76.3222
R2138 VSS.n326 VSS.n319 76.3222
R2139 VSS.n1617 VSS.n1616 76.3222
R2140 VSS.n806 VSS.n805 76.3222
R2141 VSS.n825 VSS.n824 76.3222
R2142 VSS.n800 VSS.n799 76.3222
R2143 VSS.n796 VSS.n288 76.3222
R2144 VSS.n1692 VSS.n1691 76.3222
R2145 VSS.n375 VSS.n374 76.3222
R2146 VSS.n362 VSS.n351 76.3222
R2147 VSS.n358 VSS.n324 76.3222
R2148 VSS.n1612 VSS.n1611 76.3222
R2149 VSS.n407 VSS.n322 76.3222
R2150 VSS.n897 VSS.n470 76.3222
R2151 VSS.n896 VSS.n895 76.3222
R2152 VSS.n483 VSS.n417 76.3222
R2153 VSS.n595 VSS.n419 76.3222
R2154 VSS.n563 VSS.n420 76.3222
R2155 VSS.n581 VSS.n421 76.3222
R2156 VSS.n1102 VSS.n422 76.3222
R2157 VSS.n438 VSS.n418 76.3222
R2158 VSS.n423 VSS.n418 76.3222
R2159 VSS.n1102 VSS.n1101 76.3222
R2160 VSS.n572 VSS.n421 76.3222
R2161 VSS.n582 VSS.n420 76.3222
R2162 VSS.n562 VSS.n419 76.3222
R2163 VSS.n596 VSS.n417 76.3222
R2164 VSS.n600 VSS.n599 76.3222
R2165 VSS.n566 VSS.n565 76.3222
R2166 VSS.n586 VSS.n585 76.3222
R2167 VSS.n567 VSS.n429 76.3222
R2168 VSS.n1091 VSS.n1090 76.3222
R2169 VSS.n1088 VSS.n1087 76.3222
R2170 VSS.n1089 VSS.n1088 76.3222
R2171 VSS.n1092 VSS.n1091 76.3222
R2172 VSS.n568 VSS.n567 76.3222
R2173 VSS.n587 VSS.n586 76.3222
R2174 VSS.n565 VSS.n487 76.3222
R2175 VSS.n1703 VSS.n201 76.3222
R2176 VSS.n1710 VSS.n202 76.3222
R2177 VSS.n1717 VSS.n203 76.3222
R2178 VSS.n1724 VSS.n204 76.3222
R2179 VSS.n1730 VSS.n205 76.3222
R2180 VSS.n1791 VSS.n1790 76.3222
R2181 VSS.n752 VSS.n645 76.3222
R2182 VSS.n750 VSS.n749 76.3222
R2183 VSS.n747 VSS.n746 76.3222
R2184 VSS.n735 VSS.n660 76.3222
R2185 VSS.n733 VSS.n732 76.3222
R2186 VSS.n662 VSS.n207 76.3222
R2187 VSS.n663 VSS.n662 76.3222
R2188 VSS.n734 VSS.n733 76.3222
R2189 VSS.n660 VSS.n650 76.3222
R2190 VSS.n748 VSS.n747 76.3222
R2191 VSS.n751 VSS.n750 76.3222
R2192 VSS.n763 VSS.n762 76.3222
R2193 VSS.n656 VSS.n654 76.3222
R2194 VSS.n742 VSS.n741 76.3222
R2195 VSS.n671 VSS.n669 76.3222
R2196 VSS.n728 VSS.n727 76.3222
R2197 VSS.n729 VSS.n728 76.3222
R2198 VSS.n669 VSS.n657 76.3222
R2199 VSS.n743 VSS.n742 76.3222
R2200 VSS.n654 VSS.n621 76.3222
R2201 VSS.n764 VSS.n763 76.3222
R2202 VSS.n1961 VSS.n1885 76.3222
R2203 VSS.n1959 VSS.n48 76.3222
R2204 VSS.n1988 VSS.n1987 76.3222
R2205 VSS.n1985 VSS.n1984 76.3222
R2206 VSS.n1976 VSS.n55 76.3222
R2207 VSS.n1974 VSS.n1973 76.3222
R2208 VSS.n1791 VSS.n206 76.3222
R2209 VSS.n1725 VSS.n205 76.3222
R2210 VSS.n1716 VSS.n204 76.3222
R2211 VSS.n1709 VSS.n203 76.3222
R2212 VSS.n1702 VSS.n202 76.3222
R2213 VSS.n431 VSS.n201 76.3222
R2214 VSS.n1706 VSS.n267 76.3222
R2215 VSS.n1713 VSS.n268 76.3222
R2216 VSS.n1720 VSS.n269 76.3222
R2217 VSS.n272 VSS.n270 76.3222
R2218 VSS.n1734 VSS.n271 76.3222
R2219 VSS.n1736 VSS.n266 76.3222
R2220 VSS.n1698 VSS.n1697 76.3222
R2221 VSS.n1083 VSS.n284 76.3222
R2222 VSS.n1386 VSS.n1385 76.3222
R2223 VSS.n1231 VSS.n1229 76.3222
R2224 VSS.n1393 VSS.n1392 76.3222
R2225 VSS.n1396 VSS.n1395 76.3222
R2226 VSS.n1399 VSS.n1398 76.3222
R2227 VSS.n1536 VSS.n1131 76.3222
R2228 VSS.n1359 VSS.n1130 76.3222
R2229 VSS.n1363 VSS.n1129 76.3222
R2230 VSS.n1367 VSS.n1128 76.3222
R2231 VSS.n1371 VSS.n1127 76.3222
R2232 VSS.n1375 VSS.n1126 76.3222
R2233 VSS.n1330 VSS.n1316 76.3222
R2234 VSS.n1337 VSS.n1317 76.3222
R2235 VSS.n1344 VSS.n1318 76.3222
R2236 VSS.n1321 VSS.n1319 76.3222
R2237 VSS.n1354 VSS.n1320 76.3222
R2238 VSS.n1315 VSS.n1312 76.3222
R2239 VSS.n1516 VSS.n1481 76.3222
R2240 VSS.n1748 VSS.n1747 76.3222
R2241 VSS.n1820 VSS.n164 76.3222
R2242 VSS.n1818 VSS.n1817 76.3222
R2243 VSS.n179 VSS.n177 76.3222
R2244 VSS.n1806 VSS.n1805 76.3222
R2245 VSS.n191 VSS.n190 76.3222
R2246 VSS.n190 VSS.n180 76.3222
R2247 VSS.n1807 VSS.n1806 76.3222
R2248 VSS.n177 VSS.n166 76.3222
R2249 VSS.n1819 VSS.n1818 76.3222
R2250 VSS.n1746 VSS.n164 76.3222
R2251 VSS.n1749 VSS.n1748 76.3222
R2252 VSS.n1975 VSS.n1974 76.3222
R2253 VSS.n55 VSS.n50 76.3222
R2254 VSS.n1986 VSS.n1985 76.3222
R2255 VSS.n1989 VSS.n1988 76.3222
R2256 VSS.n1960 VSS.n1959 76.3222
R2257 VSS.n1885 VSS.n125 76.3222
R2258 VSS.n645 VSS.n616 76.3222
R2259 VSS.n601 VSS.n600 76.3222
R2260 VSS.n898 VSS.n897 76.3222
R2261 VSS.n895 VSS.n894 76.3222
R2262 VSS.n1793 VSS.n192 75.2135
R2263 VSS.n1954 VSS.n1953 74.5978
R2264 VSS.n1953 VSS.n1952 74.5978
R2265 VSS.n1308 VSS.n1307 74.5978
R2266 VSS.n1605 VSS.n1604 74.5978
R2267 VSS.n1605 VSS.n1602 74.5978
R2268 VSS.n1683 VSS.n1682 74.5978
R2269 VSS.n1682 VSS.n1681 74.5978
R2270 VSS.n1831 VSS.n1830 74.5978
R2271 VSS.n1831 VSS.n156 74.5978
R2272 VSS.n1466 VSS.n1465 74.5978
R2273 VSS.n1465 VSS.n1464 74.5978
R2274 VSS.n559 VSS.n558 74.5978
R2275 VSS.n558 VSS.n557 74.5978
R2276 VSS.n757 VSS.n625 74.5978
R2277 VSS.n757 VSS.n756 74.5978
R2278 VSS.n1309 VSS.n1308 74.5978
R2279 VSS.t17 VSS.t14 72.7578
R2280 VSS.t16 VSS.t12 72.7578
R2281 VSS.n1342 VSS.n1323 69.6712
R2282 VSS.n1919 VSS.n1918 69.3109
R2283 VSS.n1918 VSS.n1917 69.3109
R2284 VSS.n75 VSS.n21 69.3109
R2285 VSS.n1274 VSS.n1273 69.3109
R2286 VSS.n1273 VSS.n1272 69.3109
R2287 VSS.n1568 VSS.n336 69.3109
R2288 VSS.n1565 VSS.n336 69.3109
R2289 VSS.n1647 VSS.n1646 69.3109
R2290 VSS.n1646 VSS.n1645 69.3109
R2291 VSS.n232 VSS.n145 69.3109
R2292 VSS.n229 VSS.n145 69.3109
R2293 VSS.n1431 VSS.n1430 69.3109
R2294 VSS.n1430 VSS.n1429 69.3109
R2295 VSS.n523 VSS.n522 69.3109
R2296 VSS.n522 VSS.n521 69.3109
R2297 VSS.n703 VSS.n632 69.3109
R2298 VSS.n706 VSS.n632 69.3109
R2299 VSS.n72 VSS.n21 69.3109
R2300 VSS.t34 VSS.n198 67.8333
R2301 VSS.t25 VSS.n404 67.1761
R2302 VSS.n1533 VSS.n1532 67.1761
R2303 VSS.t25 VSS.n287 66.1603
R2304 VSS.n1936 VSS.t35 65.8183
R2305 VSS.n1942 VSS.t35 65.8183
R2306 VSS.n1944 VSS.t35 65.8183
R2307 VSS.n1950 VSS.t35 65.8183
R2308 VSS.n1920 VSS.t35 65.8183
R2309 VSS.n1926 VSS.t35 65.8183
R2310 VSS.n1928 VSS.t35 65.8183
R2311 VSS.n1934 VSS.t35 65.8183
R2312 VSS.n1904 VSS.t35 65.8183
R2313 VSS.n1901 VSS.t35 65.8183
R2314 VSS.n1911 VSS.t35 65.8183
R2315 VSS.n1898 VSS.t35 65.8183
R2316 VSS.n1291 VSS.t32 65.8183
R2317 VSS.n1297 VSS.t32 65.8183
R2318 VSS.n1299 VSS.t32 65.8183
R2319 VSS.n1305 VSS.t32 65.8183
R2320 VSS.n1275 VSS.t32 65.8183
R2321 VSS.n1281 VSS.t32 65.8183
R2322 VSS.n1283 VSS.t32 65.8183
R2323 VSS.n1289 VSS.t32 65.8183
R2324 VSS.n1259 VSS.t32 65.8183
R2325 VSS.n1256 VSS.t32 65.8183
R2326 VSS.n1266 VSS.t32 65.8183
R2327 VSS.n1253 VSS.t32 65.8183
R2328 VSS.t24 VSS.n346 65.8183
R2329 VSS.t24 VSS.n345 65.8183
R2330 VSS.t24 VSS.n344 65.8183
R2331 VSS.t24 VSS.n343 65.8183
R2332 VSS.t24 VSS.n334 65.8183
R2333 VSS.t24 VSS.n341 65.8183
R2334 VSS.t24 VSS.n332 65.8183
R2335 VSS.t24 VSS.n342 65.8183
R2336 VSS.t24 VSS.n340 65.8183
R2337 VSS.t24 VSS.n339 65.8183
R2338 VSS.t24 VSS.n338 65.8183
R2339 VSS.t24 VSS.n337 65.8183
R2340 VSS.t24 VSS.n335 65.8183
R2341 VSS.t24 VSS.n333 65.8183
R2342 VSS.n1606 VSS.t24 65.8183
R2343 VSS.t24 VSS.n331 65.8183
R2344 VSS.n1666 VSS.t26 65.8183
R2345 VSS.n1668 VSS.t26 65.8183
R2346 VSS.n1674 VSS.t26 65.8183
R2347 VSS.n1676 VSS.t26 65.8183
R2348 VSS.n299 VSS.t26 65.8183
R2349 VSS.n1652 VSS.t26 65.8183
R2350 VSS.n1658 VSS.t26 65.8183
R2351 VSS.n1660 VSS.t26 65.8183
R2352 VSS.n1632 VSS.t26 65.8183
R2353 VSS.n306 VSS.t26 65.8183
R2354 VSS.n1639 VSS.t26 65.8183
R2355 VSS.n303 VSS.t26 65.8183
R2356 VSS.n813 VSS.t26 65.8183
R2357 VSS.n811 VSS.t26 65.8183
R2358 VSS.n808 VSS.t26 65.8183
R2359 VSS.n1686 VSS.t26 65.8183
R2360 VSS.t36 VSS.n155 65.8183
R2361 VSS.t36 VSS.n154 65.8183
R2362 VSS.t36 VSS.n153 65.8183
R2363 VSS.t36 VSS.n152 65.8183
R2364 VSS.t36 VSS.n143 65.8183
R2365 VSS.t36 VSS.n150 65.8183
R2366 VSS.t36 VSS.n141 65.8183
R2367 VSS.t36 VSS.n151 65.8183
R2368 VSS.t36 VSS.n149 65.8183
R2369 VSS.t36 VSS.n148 65.8183
R2370 VSS.t36 VSS.n147 65.8183
R2371 VSS.t36 VSS.n146 65.8183
R2372 VSS.t36 VSS.n144 65.8183
R2373 VSS.t36 VSS.n142 65.8183
R2374 VSS.n1832 VSS.t36 65.8183
R2375 VSS.t36 VSS.n140 65.8183
R2376 VSS.n1448 VSS.t28 65.8183
R2377 VSS.n1454 VSS.t28 65.8183
R2378 VSS.n1456 VSS.t28 65.8183
R2379 VSS.n1462 VSS.t28 65.8183
R2380 VSS.n1432 VSS.t28 65.8183
R2381 VSS.n1438 VSS.t28 65.8183
R2382 VSS.n1440 VSS.t28 65.8183
R2383 VSS.n1446 VSS.t28 65.8183
R2384 VSS.n1416 VSS.t28 65.8183
R2385 VSS.n1196 VSS.t28 65.8183
R2386 VSS.n1423 VSS.t28 65.8183
R2387 VSS.n1193 VSS.t28 65.8183
R2388 VSS.n1412 VSS.t28 65.8183
R2389 VSS.n1212 VSS.t28 65.8183
R2390 VSS.n1214 VSS.t28 65.8183
R2391 VSS.n1468 VSS.t28 65.8183
R2392 VSS.n542 VSS.t27 65.8183
R2393 VSS.n544 VSS.t27 65.8183
R2394 VSS.n550 VSS.t27 65.8183
R2395 VSS.n552 VSS.t27 65.8183
R2396 VSS.n499 VSS.t27 65.8183
R2397 VSS.n528 VSS.t27 65.8183
R2398 VSS.n534 VSS.t27 65.8183
R2399 VSS.n536 VSS.t27 65.8183
R2400 VSS.n508 VSS.t27 65.8183
R2401 VSS.n507 VSS.t27 65.8183
R2402 VSS.n515 VSS.t27 65.8183
R2403 VSS.n503 VSS.t27 65.8183
R2404 VSS.n1097 VSS.t27 65.8183
R2405 VSS.n577 VSS.t27 65.8183
R2406 VSS.n575 VSS.t27 65.8183
R2407 VSS.n591 VSS.t27 65.8183
R2408 VSS.t30 VSS.n642 65.8183
R2409 VSS.t30 VSS.n641 65.8183
R2410 VSS.t30 VSS.n640 65.8183
R2411 VSS.t30 VSS.n639 65.8183
R2412 VSS.t30 VSS.n630 65.8183
R2413 VSS.t30 VSS.n637 65.8183
R2414 VSS.t30 VSS.n627 65.8183
R2415 VSS.t30 VSS.n638 65.8183
R2416 VSS.t30 VSS.n636 65.8183
R2417 VSS.t30 VSS.n635 65.8183
R2418 VSS.t30 VSS.n634 65.8183
R2419 VSS.t30 VSS.n633 65.8183
R2420 VSS.t30 VSS.n631 65.8183
R2421 VSS.t30 VSS.n629 65.8183
R2422 VSS.t30 VSS.n628 65.8183
R2423 VSS.n758 VSS.t30 65.8183
R2424 VSS.n1310 VSS.n1234 65.8183
R2425 VSS.n1310 VSS.n1235 65.8183
R2426 VSS.t32 VSS.n1239 65.8183
R2427 VSS.n1310 VSS.n1236 65.8183
R2428 VSS.t32 VSS.n1240 65.8183
R2429 VSS.n1310 VSS.n1237 65.8183
R2430 VSS.t32 VSS.n1241 65.8183
R2431 VSS.t33 VSS.n14 65.8183
R2432 VSS.t33 VSS.n20 65.8183
R2433 VSS.t33 VSS.n19 65.8183
R2434 VSS.t33 VSS.n18 65.8183
R2435 VSS.t33 VSS.n17 65.8183
R2436 VSS.t33 VSS.n23 65.8183
R2437 VSS.t33 VSS.n16 65.8183
R2438 VSS.t33 VSS.n27 65.8183
R2439 VSS.t33 VSS.n28 65.8183
R2440 VSS.t33 VSS.n29 65.8183
R2441 VSS.t33 VSS.n30 65.8183
R2442 VSS.t33 VSS.n22 65.8183
R2443 VSS.t33 VSS.n24 65.8183
R2444 VSS.t33 VSS.n25 65.8183
R2445 VSS.t33 VSS.n2010 65.8183
R2446 VSS.n53 VSS.t35 65.8183
R2447 VSS.n1980 VSS.t35 65.8183
R2448 VSS.n1993 VSS.t35 65.8183
R2449 VSS.n1955 VSS.t35 65.8183
R2450 VSS.t33 VSS.n26 64.1729
R2451 VSS.n850 VSS.n784 63.0593
R2452 VSS.t31 VSS.n200 62.5209
R2453 VSS.n1968 VSS.n40 62.4163
R2454 VSS.n914 VSS.t5 62.1744
R2455 VSS.n1967 VSS.t34 58.4076
R2456 VSS.t25 VSS.n410 58.1503
R2457 VSS.t25 VSS.n413 58.1503
R2458 VSS.n1918 VSS.t35 57.8461
R2459 VSS.n1273 VSS.t32 57.8461
R2460 VSS.t24 VSS.n336 57.8461
R2461 VSS.n1646 VSS.t26 57.8461
R2462 VSS.t36 VSS.n145 57.8461
R2463 VSS.n1430 VSS.t28 57.8461
R2464 VSS.n522 VSS.t27 57.8461
R2465 VSS.t30 VSS.n632 57.8461
R2466 VSS.t33 VSS.n21 57.8461
R2467 VSS.t25 VSS.n414 57.3918
R2468 VSS.n92 VSS.n26 56.6572
R2469 VSS.n89 VSS.n26 56.6572
R2470 VSS.n1308 VSS.t32 55.2026
R2471 VSS.t24 VSS.n1605 55.2026
R2472 VSS.n1682 VSS.t26 55.2026
R2473 VSS.t36 VSS.n1831 55.2026
R2474 VSS.n1465 VSS.t28 55.2026
R2475 VSS.n558 VSS.t27 55.2026
R2476 VSS.t30 VSS.n757 55.2026
R2477 VSS.n1953 VSS.t35 55.2026
R2478 VSS.t34 VSS.n117 54.4631
R2479 VSS.n1935 VSS.n1934 53.3664
R2480 VSS.n1928 VSS.n1892 53.3664
R2481 VSS.n1927 VSS.n1926 53.3664
R2482 VSS.n1920 VSS.n1894 53.3664
R2483 VSS.n1913 VSS.n1898 53.3664
R2484 VSS.n1911 VSS.n1910 53.3664
R2485 VSS.n1906 VSS.n1901 53.3664
R2486 VSS.n1904 VSS.n1903 53.3664
R2487 VSS.n1956 VSS.n1955 53.3664
R2488 VSS.n1993 VSS.n1992 53.3664
R2489 VSS.n1980 VSS.n45 53.3664
R2490 VSS.n1979 VSS.n53 53.3664
R2491 VSS.n1936 VSS.n1890 53.3664
R2492 VSS.n1942 VSS.n1941 53.3664
R2493 VSS.n1945 VSS.n1944 53.3664
R2494 VSS.n1950 VSS.n1949 53.3664
R2495 VSS.n1937 VSS.n1936 53.3664
R2496 VSS.n1943 VSS.n1942 53.3664
R2497 VSS.n1944 VSS.n1888 53.3664
R2498 VSS.n1951 VSS.n1950 53.3664
R2499 VSS.n1921 VSS.n1920 53.3664
R2500 VSS.n1926 VSS.n1925 53.3664
R2501 VSS.n1929 VSS.n1928 53.3664
R2502 VSS.n1934 VSS.n1933 53.3664
R2503 VSS.n1905 VSS.n1904 53.3664
R2504 VSS.n1901 VSS.n1899 53.3664
R2505 VSS.n1912 VSS.n1911 53.3664
R2506 VSS.n1898 VSS.n1896 53.3664
R2507 VSS.n93 VSS.n27 53.3664
R2508 VSS.n97 VSS.n28 53.3664
R2509 VSS.n101 VSS.n29 53.3664
R2510 VSS.n105 VSS.n30 53.3664
R2511 VSS.n86 VSS.n16 53.3664
R2512 VSS.n83 VSS.n23 53.3664
R2513 VSS.n79 VSS.n17 53.3664
R2514 VSS.n68 VSS.n18 53.3664
R2515 VSS.n64 VSS.n19 53.3664
R2516 VSS.n60 VSS.n20 53.3664
R2517 VSS.n2012 VSS.n14 53.3664
R2518 VSS.n2010 VSS.n2009 53.3664
R2519 VSS.n1838 VSS.n25 53.3664
R2520 VSS.n1862 VSS.n24 53.3664
R2521 VSS.n1853 VSS.n22 53.3664
R2522 VSS.n1291 VSS.n1245 53.3664
R2523 VSS.n1297 VSS.n1296 53.3664
R2524 VSS.n1300 VSS.n1299 53.3664
R2525 VSS.n1305 VSS.n1304 53.3664
R2526 VSS.n1292 VSS.n1291 53.3664
R2527 VSS.n1298 VSS.n1297 53.3664
R2528 VSS.n1299 VSS.n1243 53.3664
R2529 VSS.n1306 VSS.n1305 53.3664
R2530 VSS.n1290 VSS.n1289 53.3664
R2531 VSS.n1283 VSS.n1247 53.3664
R2532 VSS.n1282 VSS.n1281 53.3664
R2533 VSS.n1275 VSS.n1249 53.3664
R2534 VSS.n1276 VSS.n1275 53.3664
R2535 VSS.n1281 VSS.n1280 53.3664
R2536 VSS.n1284 VSS.n1283 53.3664
R2537 VSS.n1289 VSS.n1288 53.3664
R2538 VSS.n1268 VSS.n1253 53.3664
R2539 VSS.n1266 VSS.n1265 53.3664
R2540 VSS.n1261 VSS.n1256 53.3664
R2541 VSS.n1259 VSS.n1258 53.3664
R2542 VSS.n1260 VSS.n1259 53.3664
R2543 VSS.n1256 VSS.n1254 53.3664
R2544 VSS.n1267 VSS.n1266 53.3664
R2545 VSS.n1253 VSS.n1251 53.3664
R2546 VSS.n1257 VSS.n1234 53.3664
R2547 VSS.n1584 VSS.n342 53.3664
R2548 VSS.n1580 VSS.n332 53.3664
R2549 VSS.n1576 VSS.n341 53.3664
R2550 VSS.n1572 VSS.n334 53.3664
R2551 VSS.n1561 VSS.n337 53.3664
R2552 VSS.n1557 VSS.n338 53.3664
R2553 VSS.n1553 VSS.n339 53.3664
R2554 VSS.n1549 VSS.n340 53.3664
R2555 VSS.n1603 VSS.n331 53.3664
R2556 VSS.n1607 VSS.n1606 53.3664
R2557 VSS.n356 VSS.n333 53.3664
R2558 VSS.n370 VSS.n335 53.3664
R2559 VSS.n1588 VSS.n346 53.3664
R2560 VSS.n1589 VSS.n345 53.3664
R2561 VSS.n1593 VSS.n344 53.3664
R2562 VSS.n1597 VSS.n343 53.3664
R2563 VSS.n1585 VSS.n346 53.3664
R2564 VSS.n1592 VSS.n345 53.3664
R2565 VSS.n1596 VSS.n344 53.3664
R2566 VSS.n347 VSS.n343 53.3664
R2567 VSS.n1569 VSS.n334 53.3664
R2568 VSS.n1573 VSS.n341 53.3664
R2569 VSS.n1577 VSS.n332 53.3664
R2570 VSS.n1581 VSS.n342 53.3664
R2571 VSS.n1552 VSS.n340 53.3664
R2572 VSS.n1556 VSS.n339 53.3664
R2573 VSS.n1560 VSS.n338 53.3664
R2574 VSS.n1564 VSS.n337 53.3664
R2575 VSS.n1548 VSS.n335 53.3664
R2576 VSS.n369 VSS.n333 53.3664
R2577 VSS.n1606 VSS.n330 53.3664
R2578 VSS.n331 VSS.n329 53.3664
R2579 VSS.n1660 VSS.n296 53.3664
R2580 VSS.n1659 VSS.n1658 53.3664
R2581 VSS.n1652 VSS.n298 53.3664
R2582 VSS.n1651 VSS.n299 53.3664
R2583 VSS.n1641 VSS.n303 53.3664
R2584 VSS.n1639 VSS.n1638 53.3664
R2585 VSS.n1634 VSS.n306 53.3664
R2586 VSS.n1632 VSS.n1631 53.3664
R2587 VSS.n1686 VSS.n1685 53.3664
R2588 VSS.n808 VSS.n291 53.3664
R2589 VSS.n811 VSS.n810 53.3664
R2590 VSS.n814 VSS.n813 53.3664
R2591 VSS.n1667 VSS.n1666 53.3664
R2592 VSS.n1669 VSS.n1668 53.3664
R2593 VSS.n1674 VSS.n1673 53.3664
R2594 VSS.n1677 VSS.n1676 53.3664
R2595 VSS.n1666 VSS.n1665 53.3664
R2596 VSS.n1668 VSS.n294 53.3664
R2597 VSS.n1675 VSS.n1674 53.3664
R2598 VSS.n1676 VSS.n292 53.3664
R2599 VSS.n1648 VSS.n299 53.3664
R2600 VSS.n1653 VSS.n1652 53.3664
R2601 VSS.n1658 VSS.n1657 53.3664
R2602 VSS.n1661 VSS.n1660 53.3664
R2603 VSS.n1633 VSS.n1632 53.3664
R2604 VSS.n306 VSS.n304 53.3664
R2605 VSS.n1640 VSS.n1639 53.3664
R2606 VSS.n303 VSS.n301 53.3664
R2607 VSS.n813 VSS.n307 53.3664
R2608 VSS.n812 VSS.n811 53.3664
R2609 VSS.n809 VSS.n808 53.3664
R2610 VSS.n1687 VSS.n1686 53.3664
R2611 VSS.n248 VSS.n151 53.3664
R2612 VSS.n244 VSS.n141 53.3664
R2613 VSS.n240 VSS.n150 53.3664
R2614 VSS.n236 VSS.n143 53.3664
R2615 VSS.n225 VSS.n146 53.3664
R2616 VSS.n221 VSS.n147 53.3664
R2617 VSS.n217 VSS.n148 53.3664
R2618 VSS.n1801 VSS.n149 53.3664
R2619 VSS.n157 VSS.n140 53.3664
R2620 VSS.n1833 VSS.n1832 53.3664
R2621 VSS.n169 VSS.n142 53.3664
R2622 VSS.n175 VSS.n144 53.3664
R2623 VSS.n252 VSS.n155 53.3664
R2624 VSS.n253 VSS.n154 53.3664
R2625 VSS.n257 VSS.n153 53.3664
R2626 VSS.n261 VSS.n152 53.3664
R2627 VSS.n249 VSS.n155 53.3664
R2628 VSS.n256 VSS.n154 53.3664
R2629 VSS.n260 VSS.n153 53.3664
R2630 VSS.n263 VSS.n152 53.3664
R2631 VSS.n233 VSS.n143 53.3664
R2632 VSS.n237 VSS.n150 53.3664
R2633 VSS.n241 VSS.n141 53.3664
R2634 VSS.n245 VSS.n151 53.3664
R2635 VSS.n216 VSS.n149 53.3664
R2636 VSS.n220 VSS.n148 53.3664
R2637 VSS.n224 VSS.n147 53.3664
R2638 VSS.n228 VSS.n146 53.3664
R2639 VSS.n1802 VSS.n144 53.3664
R2640 VSS.n174 VSS.n142 53.3664
R2641 VSS.n1832 VSS.n139 53.3664
R2642 VSS.n140 VSS.n138 53.3664
R2643 VSS.n1447 VSS.n1446 53.3664
R2644 VSS.n1440 VSS.n1187 53.3664
R2645 VSS.n1439 VSS.n1438 53.3664
R2646 VSS.n1432 VSS.n1189 53.3664
R2647 VSS.n1425 VSS.n1193 53.3664
R2648 VSS.n1423 VSS.n1422 53.3664
R2649 VSS.n1418 VSS.n1196 53.3664
R2650 VSS.n1416 VSS.n1415 53.3664
R2651 VSS.n1468 VSS.n1467 53.3664
R2652 VSS.n1214 VSS.n1181 53.3664
R2653 VSS.n1213 VSS.n1212 53.3664
R2654 VSS.n1412 VSS.n1411 53.3664
R2655 VSS.n1448 VSS.n1185 53.3664
R2656 VSS.n1454 VSS.n1453 53.3664
R2657 VSS.n1457 VSS.n1456 53.3664
R2658 VSS.n1462 VSS.n1461 53.3664
R2659 VSS.n1449 VSS.n1448 53.3664
R2660 VSS.n1455 VSS.n1454 53.3664
R2661 VSS.n1456 VSS.n1183 53.3664
R2662 VSS.n1463 VSS.n1462 53.3664
R2663 VSS.n1433 VSS.n1432 53.3664
R2664 VSS.n1438 VSS.n1437 53.3664
R2665 VSS.n1441 VSS.n1440 53.3664
R2666 VSS.n1446 VSS.n1445 53.3664
R2667 VSS.n1417 VSS.n1416 53.3664
R2668 VSS.n1196 VSS.n1194 53.3664
R2669 VSS.n1424 VSS.n1423 53.3664
R2670 VSS.n1193 VSS.n1191 53.3664
R2671 VSS.n1413 VSS.n1412 53.3664
R2672 VSS.n1212 VSS.n1198 53.3664
R2673 VSS.n1215 VSS.n1214 53.3664
R2674 VSS.n1469 VSS.n1468 53.3664
R2675 VSS.n536 VSS.n496 53.3664
R2676 VSS.n535 VSS.n534 53.3664
R2677 VSS.n528 VSS.n498 53.3664
R2678 VSS.n527 VSS.n499 53.3664
R2679 VSS.n517 VSS.n503 53.3664
R2680 VSS.n515 VSS.n514 53.3664
R2681 VSS.n510 VSS.n507 53.3664
R2682 VSS.n508 VSS.n426 53.3664
R2683 VSS.n592 VSS.n591 53.3664
R2684 VSS.n575 VSS.n560 53.3664
R2685 VSS.n578 VSS.n577 53.3664
R2686 VSS.n1097 VSS.n1096 53.3664
R2687 VSS.n543 VSS.n542 53.3664
R2688 VSS.n545 VSS.n544 53.3664
R2689 VSS.n550 VSS.n549 53.3664
R2690 VSS.n553 VSS.n552 53.3664
R2691 VSS.n542 VSS.n541 53.3664
R2692 VSS.n544 VSS.n494 53.3664
R2693 VSS.n551 VSS.n550 53.3664
R2694 VSS.n552 VSS.n492 53.3664
R2695 VSS.n524 VSS.n499 53.3664
R2696 VSS.n529 VSS.n528 53.3664
R2697 VSS.n534 VSS.n533 53.3664
R2698 VSS.n537 VSS.n536 53.3664
R2699 VSS.n509 VSS.n508 53.3664
R2700 VSS.n507 VSS.n504 53.3664
R2701 VSS.n516 VSS.n515 53.3664
R2702 VSS.n503 VSS.n501 53.3664
R2703 VSS.n1098 VSS.n1097 53.3664
R2704 VSS.n577 VSS.n427 53.3664
R2705 VSS.n576 VSS.n575 53.3664
R2706 VSS.n591 VSS.n590 53.3664
R2707 VSS.n687 VSS.n638 53.3664
R2708 VSS.n691 VSS.n627 53.3664
R2709 VSS.n695 VSS.n637 53.3664
R2710 VSS.n699 VSS.n630 53.3664
R2711 VSS.n710 VSS.n633 53.3664
R2712 VSS.n714 VSS.n634 53.3664
R2713 VSS.n718 VSS.n635 53.3664
R2714 VSS.n722 VSS.n636 53.3664
R2715 VSS.n759 VSS.n758 53.3664
R2716 VSS.n651 VSS.n628 53.3664
R2717 VSS.n738 VSS.n629 53.3664
R2718 VSS.n666 VSS.n631 53.3664
R2719 VSS.n683 VSS.n642 53.3664
R2720 VSS.n682 VSS.n641 53.3664
R2721 VSS.n678 VSS.n640 53.3664
R2722 VSS.n674 VSS.n639 53.3664
R2723 VSS.n686 VSS.n642 53.3664
R2724 VSS.n679 VSS.n641 53.3664
R2725 VSS.n675 VSS.n640 53.3664
R2726 VSS.n643 VSS.n639 53.3664
R2727 VSS.n702 VSS.n630 53.3664
R2728 VSS.n698 VSS.n637 53.3664
R2729 VSS.n694 VSS.n627 53.3664
R2730 VSS.n690 VSS.n638 53.3664
R2731 VSS.n719 VSS.n636 53.3664
R2732 VSS.n715 VSS.n635 53.3664
R2733 VSS.n711 VSS.n634 53.3664
R2734 VSS.n707 VSS.n633 53.3664
R2735 VSS.n721 VSS.n631 53.3664
R2736 VSS.n665 VSS.n629 53.3664
R2737 VSS.n737 VSS.n628 53.3664
R2738 VSS.n758 VSS.n626 53.3664
R2739 VSS.n1238 VSS.n1237 53.3664
R2740 VSS.n22 VSS.n15 53.3664
R2741 VSS.n59 VSS.n14 53.3664
R2742 VSS.n63 VSS.n20 53.3664
R2743 VSS.n67 VSS.n19 53.3664
R2744 VSS.n71 VSS.n18 53.3664
R2745 VSS.n76 VSS.n17 53.3664
R2746 VSS.n80 VSS.n23 53.3664
R2747 VSS.n84 VSS.n16 53.3664
R2748 VSS.n96 VSS.n27 53.3664
R2749 VSS.n100 VSS.n28 53.3664
R2750 VSS.n104 VSS.n29 53.3664
R2751 VSS.n33 VSS.n30 53.3664
R2752 VSS.n1852 VSS.n24 53.3664
R2753 VSS.n1863 VSS.n25 53.3664
R2754 VSS.n2010 VSS.n32 53.3664
R2755 VSS.n1902 VSS.n53 53.3664
R2756 VSS.n1981 VSS.n1980 53.3664
R2757 VSS.n1994 VSS.n1993 53.3664
R2758 VSS.n1955 VSS.n46 53.3664
R2759 VSS.t38 VSS.n38 51.4374
R2760 VSS.t22 VSS.n114 51.4374
R2761 VSS.t0 VSS.n1008 47.8266
R2762 VSS.n842 VSS.t17 42.4428
R2763 VSS.n1998 VSS.t40 40.8142
R2764 VSS.n844 VSS.t15 40.8142
R2765 VSS.t34 VSS.t39 40.478
R2766 VSS.t12 VSS 34.162
R2767 VSS.n1998 VSS 33.275
R2768 VSS.n844 VSS 33.275
R2769 VSS.n932 VSS.t4 31.0875
R2770 VSS.n838 VSS 30.9923
R2771 VSS.n842 VSS.t16 30.3166
R2772 VSS.n2004 VSS.n39 30.0054
R2773 VSS.t31 VSS.n199 29.7233
R2774 VSS.n848 VSS.n847 24.1492
R2775 VSS.n1916 VSS.n1895 23.6449
R2776 VSS.n1271 VSS.n1250 23.6449
R2777 VSS.n1567 VSS.n1566 23.6449
R2778 VSS.n1644 VSS.n300 23.6449
R2779 VSS.n231 VSS.n230 23.6449
R2780 VSS.n1428 VSS.n1190 23.6449
R2781 VSS.n520 VSS.n500 23.6449
R2782 VSS.n705 VSS.n704 23.6449
R2783 VSS.n74 VSS.n73 23.6449
R2784 VSS VSS.n476 22.927
R2785 VSS.t13 VSS.n2017 21.4326
R2786 VSS.n848 VSS.n843 17.9785
R2787 VSS.n1938 VSS.n1891 17.4227
R2788 VSS.n1293 VSS.n1246 17.4227
R2789 VSS.n1586 VSS.n1583 17.4227
R2790 VSS.n1664 VSS.n1663 17.4227
R2791 VSS.n250 VSS.n247 17.4227
R2792 VSS.n1450 VSS.n1186 17.4227
R2793 VSS.n540 VSS.n539 17.4227
R2794 VSS.n688 VSS.n685 17.4227
R2795 VSS.n91 VSS.n90 17.4227
R2796 VSS.n434 VSS.n280 16.9587
R2797 VSS.n1939 VSS.n1938 16.0005
R2798 VSS.n1940 VSS.n1939 16.0005
R2799 VSS.n1940 VSS.n1889 16.0005
R2800 VSS.n1946 VSS.n1889 16.0005
R2801 VSS.n1947 VSS.n1946 16.0005
R2802 VSS.n1948 VSS.n1947 16.0005
R2803 VSS.n1948 VSS.n1887 16.0005
R2804 VSS.n1887 VSS.n42 16.0005
R2805 VSS.n1932 VSS.n1891 16.0005
R2806 VSS.n1932 VSS.n1931 16.0005
R2807 VSS.n1931 VSS.n1930 16.0005
R2808 VSS.n1930 VSS.n1893 16.0005
R2809 VSS.n1924 VSS.n1893 16.0005
R2810 VSS.n1923 VSS.n1922 16.0005
R2811 VSS.n1922 VSS.n1895 16.0005
R2812 VSS.n1916 VSS.n1915 16.0005
R2813 VSS.n1915 VSS.n1914 16.0005
R2814 VSS.n1914 VSS.n1897 16.0005
R2815 VSS.n1909 VSS.n1897 16.0005
R2816 VSS.n1909 VSS.n1908 16.0005
R2817 VSS.n1908 VSS.n1907 16.0005
R2818 VSS.n1907 VSS.n1900 16.0005
R2819 VSS.n1900 VSS.n43 16.0005
R2820 VSS.n1287 VSS.n1246 16.0005
R2821 VSS.n1287 VSS.n1286 16.0005
R2822 VSS.n1286 VSS.n1285 16.0005
R2823 VSS.n1285 VSS.n1248 16.0005
R2824 VSS.n1279 VSS.n1248 16.0005
R2825 VSS.n1278 VSS.n1277 16.0005
R2826 VSS.n1277 VSS.n1250 16.0005
R2827 VSS.n1271 VSS.n1270 16.0005
R2828 VSS.n1270 VSS.n1269 16.0005
R2829 VSS.n1269 VSS.n1252 16.0005
R2830 VSS.n1264 VSS.n1252 16.0005
R2831 VSS.n1264 VSS.n1263 16.0005
R2832 VSS.n1263 VSS.n1262 16.0005
R2833 VSS.n1262 VSS.n1255 16.0005
R2834 VSS.n1255 VSS.n1233 16.0005
R2835 VSS.n1294 VSS.n1293 16.0005
R2836 VSS.n1295 VSS.n1294 16.0005
R2837 VSS.n1295 VSS.n1244 16.0005
R2838 VSS.n1301 VSS.n1244 16.0005
R2839 VSS.n1302 VSS.n1301 16.0005
R2840 VSS.n1303 VSS.n1302 16.0005
R2841 VSS.n1303 VSS.n1242 16.0005
R2842 VSS.n1242 VSS.n1232 16.0005
R2843 VSS.n1587 VSS.n1586 16.0005
R2844 VSS.n1590 VSS.n1587 16.0005
R2845 VSS.n1591 VSS.n1590 16.0005
R2846 VSS.n1594 VSS.n1591 16.0005
R2847 VSS.n1595 VSS.n1594 16.0005
R2848 VSS.n1598 VSS.n1595 16.0005
R2849 VSS.n1599 VSS.n1598 16.0005
R2850 VSS.n1601 VSS.n1599 16.0005
R2851 VSS.n1583 VSS.n1582 16.0005
R2852 VSS.n1582 VSS.n1579 16.0005
R2853 VSS.n1579 VSS.n1578 16.0005
R2854 VSS.n1578 VSS.n1575 16.0005
R2855 VSS.n1575 VSS.n1574 16.0005
R2856 VSS.n1571 VSS.n1570 16.0005
R2857 VSS.n1570 VSS.n1567 16.0005
R2858 VSS.n1566 VSS.n1563 16.0005
R2859 VSS.n1563 VSS.n1562 16.0005
R2860 VSS.n1562 VSS.n1559 16.0005
R2861 VSS.n1559 VSS.n1558 16.0005
R2862 VSS.n1558 VSS.n1555 16.0005
R2863 VSS.n1555 VSS.n1554 16.0005
R2864 VSS.n1554 VSS.n1551 16.0005
R2865 VSS.n1551 VSS.n1550 16.0005
R2866 VSS.n1664 VSS.n295 16.0005
R2867 VSS.n1670 VSS.n295 16.0005
R2868 VSS.n1671 VSS.n1670 16.0005
R2869 VSS.n1672 VSS.n1671 16.0005
R2870 VSS.n1672 VSS.n293 16.0005
R2871 VSS.n1678 VSS.n293 16.0005
R2872 VSS.n1679 VSS.n1678 16.0005
R2873 VSS.n1680 VSS.n1679 16.0005
R2874 VSS.n1663 VSS.n1662 16.0005
R2875 VSS.n1662 VSS.n297 16.0005
R2876 VSS.n1656 VSS.n297 16.0005
R2877 VSS.n1656 VSS.n1655 16.0005
R2878 VSS.n1655 VSS.n1654 16.0005
R2879 VSS.n1650 VSS.n1649 16.0005
R2880 VSS.n1649 VSS.n300 16.0005
R2881 VSS.n1644 VSS.n1643 16.0005
R2882 VSS.n1643 VSS.n1642 16.0005
R2883 VSS.n1642 VSS.n302 16.0005
R2884 VSS.n1637 VSS.n302 16.0005
R2885 VSS.n1637 VSS.n1636 16.0005
R2886 VSS.n1636 VSS.n1635 16.0005
R2887 VSS.n1635 VSS.n305 16.0005
R2888 VSS.n1630 VSS.n305 16.0005
R2889 VSS.n251 VSS.n250 16.0005
R2890 VSS.n254 VSS.n251 16.0005
R2891 VSS.n255 VSS.n254 16.0005
R2892 VSS.n258 VSS.n255 16.0005
R2893 VSS.n259 VSS.n258 16.0005
R2894 VSS.n262 VSS.n259 16.0005
R2895 VSS.n264 VSS.n262 16.0005
R2896 VSS.n265 VSS.n264 16.0005
R2897 VSS.n247 VSS.n246 16.0005
R2898 VSS.n246 VSS.n243 16.0005
R2899 VSS.n243 VSS.n242 16.0005
R2900 VSS.n242 VSS.n239 16.0005
R2901 VSS.n239 VSS.n238 16.0005
R2902 VSS.n235 VSS.n234 16.0005
R2903 VSS.n234 VSS.n231 16.0005
R2904 VSS.n230 VSS.n227 16.0005
R2905 VSS.n227 VSS.n226 16.0005
R2906 VSS.n226 VSS.n223 16.0005
R2907 VSS.n223 VSS.n222 16.0005
R2908 VSS.n222 VSS.n219 16.0005
R2909 VSS.n219 VSS.n218 16.0005
R2910 VSS.n218 VSS.n183 16.0005
R2911 VSS.n1800 VSS.n183 16.0005
R2912 VSS.n1451 VSS.n1450 16.0005
R2913 VSS.n1452 VSS.n1451 16.0005
R2914 VSS.n1452 VSS.n1184 16.0005
R2915 VSS.n1458 VSS.n1184 16.0005
R2916 VSS.n1459 VSS.n1458 16.0005
R2917 VSS.n1460 VSS.n1459 16.0005
R2918 VSS.n1460 VSS.n1182 16.0005
R2919 VSS.n1182 VSS.n1170 16.0005
R2920 VSS.n1444 VSS.n1186 16.0005
R2921 VSS.n1444 VSS.n1443 16.0005
R2922 VSS.n1443 VSS.n1442 16.0005
R2923 VSS.n1442 VSS.n1188 16.0005
R2924 VSS.n1436 VSS.n1188 16.0005
R2925 VSS.n1435 VSS.n1434 16.0005
R2926 VSS.n1434 VSS.n1190 16.0005
R2927 VSS.n1428 VSS.n1427 16.0005
R2928 VSS.n1427 VSS.n1426 16.0005
R2929 VSS.n1426 VSS.n1192 16.0005
R2930 VSS.n1421 VSS.n1192 16.0005
R2931 VSS.n1421 VSS.n1420 16.0005
R2932 VSS.n1420 VSS.n1419 16.0005
R2933 VSS.n1419 VSS.n1195 16.0005
R2934 VSS.n1414 VSS.n1195 16.0005
R2935 VSS.n540 VSS.n495 16.0005
R2936 VSS.n546 VSS.n495 16.0005
R2937 VSS.n547 VSS.n546 16.0005
R2938 VSS.n548 VSS.n547 16.0005
R2939 VSS.n548 VSS.n493 16.0005
R2940 VSS.n554 VSS.n493 16.0005
R2941 VSS.n555 VSS.n554 16.0005
R2942 VSS.n556 VSS.n555 16.0005
R2943 VSS.n539 VSS.n538 16.0005
R2944 VSS.n538 VSS.n497 16.0005
R2945 VSS.n532 VSS.n497 16.0005
R2946 VSS.n532 VSS.n531 16.0005
R2947 VSS.n531 VSS.n530 16.0005
R2948 VSS.n526 VSS.n525 16.0005
R2949 VSS.n525 VSS.n500 16.0005
R2950 VSS.n520 VSS.n519 16.0005
R2951 VSS.n519 VSS.n518 16.0005
R2952 VSS.n518 VSS.n502 16.0005
R2953 VSS.n513 VSS.n502 16.0005
R2954 VSS.n513 VSS.n512 16.0005
R2955 VSS.n512 VSS.n511 16.0005
R2956 VSS.n511 VSS.n506 16.0005
R2957 VSS.n506 VSS.n505 16.0005
R2958 VSS.n685 VSS.n684 16.0005
R2959 VSS.n684 VSS.n681 16.0005
R2960 VSS.n681 VSS.n680 16.0005
R2961 VSS.n680 VSS.n677 16.0005
R2962 VSS.n677 VSS.n676 16.0005
R2963 VSS.n676 VSS.n673 16.0005
R2964 VSS.n673 VSS.n644 16.0005
R2965 VSS.n755 VSS.n644 16.0005
R2966 VSS.n689 VSS.n688 16.0005
R2967 VSS.n692 VSS.n689 16.0005
R2968 VSS.n693 VSS.n692 16.0005
R2969 VSS.n696 VSS.n693 16.0005
R2970 VSS.n697 VSS.n696 16.0005
R2971 VSS.n701 VSS.n700 16.0005
R2972 VSS.n704 VSS.n701 16.0005
R2973 VSS.n708 VSS.n705 16.0005
R2974 VSS.n709 VSS.n708 16.0005
R2975 VSS.n712 VSS.n709 16.0005
R2976 VSS.n713 VSS.n712 16.0005
R2977 VSS.n716 VSS.n713 16.0005
R2978 VSS.n717 VSS.n716 16.0005
R2979 VSS.n720 VSS.n717 16.0005
R2980 VSS.n723 VSS.n720 16.0005
R2981 VSS.n73 VSS.n70 16.0005
R2982 VSS.n70 VSS.n69 16.0005
R2983 VSS.n69 VSS.n66 16.0005
R2984 VSS.n66 VSS.n65 16.0005
R2985 VSS.n65 VSS.n62 16.0005
R2986 VSS.n62 VSS.n61 16.0005
R2987 VSS.n61 VSS.n13 16.0005
R2988 VSS.n2013 VSS.n13 16.0005
R2989 VSS.n90 VSS.n88 16.0005
R2990 VSS.n88 VSS.n87 16.0005
R2991 VSS.n87 VSS.n85 16.0005
R2992 VSS.n85 VSS.n82 16.0005
R2993 VSS.n82 VSS.n81 16.0005
R2994 VSS.n78 VSS.n77 16.0005
R2995 VSS.n77 VSS.n74 16.0005
R2996 VSS.n94 VSS.n91 16.0005
R2997 VSS.n95 VSS.n94 16.0005
R2998 VSS.n98 VSS.n95 16.0005
R2999 VSS.n99 VSS.n98 16.0005
R3000 VSS.n102 VSS.n99 16.0005
R3001 VSS.n103 VSS.n102 16.0005
R3002 VSS.n106 VSS.n103 16.0005
R3003 VSS.n107 VSS.n106 16.0005
R3004 VSS.n1314 VSS.n6 15.3015
R3005 VSS.n860 VSS.n859 14.3494
R3006 VSS.n1550 VSS.n348 13.6894
R3007 VSS.n1630 VSS.n1629 13.6894
R3008 VSS.n1800 VSS.n1799 13.6894
R3009 VSS.n1414 VSS.n1121 13.6894
R3010 VSS.n505 VSS.n437 13.6894
R3011 VSS.n725 VSS.n723 13.6894
R3012 VSS.n2014 VSS.n2013 13.6894
R3013 VSS.n434 VSS.n198 13.0453
R3014 VSS VSS.n1923 12.9783
R3015 VSS VSS.n1278 12.9783
R3016 VSS.n1571 VSS 12.9783
R3017 VSS.n1650 VSS 12.9783
R3018 VSS.n235 VSS 12.9783
R3019 VSS VSS.n1435 12.9783
R3020 VSS.n526 VSS 12.9783
R3021 VSS.n700 VSS 12.9783
R3022 VSS.n78 VSS 12.9783
R3023 VSS.n2005 VSS.t18 12.8597
R3024 VSS.t37 VSS.n115 12.8597
R3025 VSS.n1538 VSS.n4 12.1444
R3026 VSS.n1792 VSS.n196 11.9733
R3027 VSS.n1601 VSS.n1600 10.3116
R3028 VSS.n1680 VSS.n282 10.3116
R3029 VSS.n1744 VSS.n265 10.3116
R3030 VSS.n1478 VSS.n1170 10.3116
R3031 VSS.n556 VSS.n488 10.3116
R3032 VSS.n755 VSS.n754 10.3116
R3033 VSS.n108 VSS.n107 10.3116
R3034 VSS.n851 VSS 9.95512
R3035 VSS.n853 VSS 9.60535
R3036 VSS.n1847 VSS.n1846 9.20611
R3037 VSS.n856 VSS.n783 9.00464
R3038 VSS.n1971 VSS.n1970 8.78595
R3039 VSS.n1970 VSS.n1969 8.72777
R3040 VSS.n849 VSS.n848 8.72521
R3041 VSS.n850 VSS.n849 8.01879
R3042 VSS.n602 VSS.n486 7.61523
R3043 VSS.n1542 VSS.n378 7.51963
R3044 VSS VSS.n3 7.4634
R3045 VSS.n766 VSS.n619 6.96898
R3046 VSS.n1540 VSS.n1123 6.64531
R3047 VSS.n1538 VSS.n1537 6.41113
R3048 VSS.n838 VSS.n783 6.0212
R3049 VSS.n1793 VSS.n0 588.939
R3050 VSS.t34 VSS.n197 5.98689
R3051 VSS.n1735 VSS.n119 5.98689
R3052 VSS.n1964 VSS.n1883 5.92639
R3053 VSS.n1085 VSS.n279 5.90608
R3054 VSS.n1969 VSS.n109 5.87686
R3055 VSS.n1964 VSS.n1963 5.87686
R3056 VSS.n1972 VSS.n1971 5.58595
R3057 VSS.n851 VSS 5.42675
R3058 VSS.t25 VSS.n415 5.3017
R3059 VSS.n1963 VSS.n1962 5.23686
R3060 VSS.n1972 VSS.n56 5.23686
R3061 VSS.n855 VSS.n852 4.91661
R3062 VSS.n1029 VSS.n945 4.88894
R3063 VSS.n927 VSS.n456 4.88894
R3064 VSS.n1117 VSS.n1116 4.87323
R3065 VSS.n2000 VSS.n1999 4.79524
R3066 VSS.n846 VSS.n845 4.76815
R3067 VSS.n854 VSS.n783 4.5605
R3068 VSS.n855 VSS.n854 4.06199
R3069 VSS.n1794 VSS.n189 4.04261
R3070 VSS.n1480 VSS.n1168 4.04261
R3071 VSS.n873 VSS.n603 4.04261
R3072 VSS.n607 VSS.n603 4.04261
R3073 VSS.n866 VSS.n865 4.04261
R3074 VSS.n865 VSS.n864 4.04261
R3075 VSS.n864 VSS.n609 4.04261
R3076 VSS.n611 VSS.n609 4.04261
R3077 VSS.n614 VSS.n611 4.04261
R3078 VSS.n779 VSS.n614 4.04261
R3079 VSS.n779 VSS.n778 4.04261
R3080 VSS.n608 VSS.n607 3.99769
R3081 VSS.n1788 VSS.n209 3.98871
R3082 VSS.n1739 VSS.n1737 3.98871
R3083 VSS.n771 VSS.n767 3.98666
R3084 VSS.n767 VSS.n134 3.98666
R3085 VSS.n1868 VSS.n134 3.98666
R3086 VSS.n1874 VSS.n130 3.98666
R3087 VSS.n1875 VSS.n1874 3.98666
R3088 VSS.n1876 VSS.n1875 3.98666
R3089 VSS.n1876 VSS.n126 3.98666
R3090 VSS.n1882 VSS.n126 3.98666
R3091 VSS.n1883 VSS.n1882 3.98666
R3092 VSS.n889 VSS.n888 3.98666
R3093 VSS.n888 VSS.n887 3.98666
R3094 VSS.n881 VSS.n481 3.98666
R3095 VSS.n881 VSS.n880 3.97863
R3096 VSS.n874 VSS.n873 3.83497
R3097 VSS.n1115 VSS.n383 3.81507
R3098 VSS.n1109 VSS.n383 3.81507
R3099 VSS.n1109 VSS.n1108 3.81507
R3100 VSS.n1108 VSS.n379 3.81507
R3101 VSS.n393 VSS.n380 3.81507
R3102 VSS.n393 VSS.n392 3.81507
R3103 VSS.n399 VSS.n392 3.81507
R3104 VSS.n400 VSS.n399 3.81507
R3105 VSS.n1152 VSS.n1145 3.81507
R3106 VSS.n1153 VSS.n1152 3.81507
R3107 VSS.n1154 VSS.n1153 3.81507
R3108 VSS.n1154 VSS.n1119 3.81507
R3109 VSS.n1521 VSS.n1120 3.81507
R3110 VSS.n1522 VSS.n1521 3.81507
R3111 VSS.n1522 VSS.n1139 3.81507
R3112 VSS.n1528 VSS.n1139 3.81507
R3113 VSS.n1529 VSS.n1528 3.81507
R3114 VSS.n1401 VSS.n1400 3.81507
R3115 VSS.n1400 VSS.n1227 3.81507
R3116 VSS.n1228 VSS.n1227 3.81507
R3117 VSS.n1228 VSS.n1124 3.81507
R3118 VSS.n1390 VSS.n1125 3.81507
R3119 VSS.n1390 VSS.n1389 3.81507
R3120 VSS.n1389 VSS.n1388 3.81507
R3121 VSS.n1388 VSS.n1230 3.81507
R3122 VSS.n1383 VSS.n1230 3.81507
R3123 VSS.n1867 VSS.n130 3.8095
R3124 VSS.n401 VSS.n400 3.80766
R3125 VSS.n772 VSS.n771 3.80391
R3126 VSS.n619 VSS.n615 3.77815
R3127 VSS.n1116 VSS.n382 3.74595
R3128 VSS.n1624 VSS.n1623 3.65764
R3129 VSS.n1622 VSS.n1621 3.65764
R3130 VSS.n1147 VSS.n1145 3.6372
R3131 VSS.n1402 VSS.n1401 3.6372
R3132 VSS.n778 VSS.n777 3.62257
R3133 VSS.n1005 VSS.n382 3.49141
R3134 VSS.n481 VSS.n477 3.36659
R3135 VSS.n1530 VSS.n1529 3.36297
R3136 VSS.n4 VSS 3.288
R3137 VSS.n936 VSS.n459 3.27323
R3138 VSS.n1047 VSS.n936 3.27323
R3139 VSS.n1047 VSS.n1046 3.27323
R3140 VSS.n1046 VSS.n1045 3.27323
R3141 VSS.n1045 VSS.n937 3.27323
R3142 VSS.n1039 VSS.n937 3.27323
R3143 VSS.n1038 VSS.n1037 3.27323
R3144 VSS.n1037 VSS.n941 3.27323
R3145 VSS.n1031 VSS.n941 3.27323
R3146 VSS.n1031 VSS.n1030 3.27323
R3147 VSS.n907 VSS.n469 3.27323
R3148 VSS.n910 VSS.n909 3.27323
R3149 VSS.n910 VSS.n465 3.27323
R3150 VSS.n917 VSS.n465 3.27323
R3151 VSS.n918 VSS.n917 3.27323
R3152 VSS.n919 VSS.n462 3.27323
R3153 VSS.n925 VSS.n462 3.27323
R3154 VSS.n926 VSS.n925 3.27323
R3155 VSS.n928 VSS.n926 3.27323
R3156 VSS.n1028 VSS.n946 3.27323
R3157 VSS.n1022 VSS.n946 3.27323
R3158 VSS.n1022 VSS.n1021 3.27323
R3159 VSS.n1021 VSS.n1020 3.27323
R3160 VSS.n1020 VSS.n995 3.27323
R3161 VSS.n1014 VSS.n995 3.27323
R3162 VSS.n1013 VSS.n1012 3.27323
R3163 VSS.n1012 VSS.n1000 3.27323
R3164 VSS.n1006 VSS.n1000 3.27323
R3165 VSS.n1006 VSS.n1005 3.27323
R3166 VSS.n880 VSS.n879 3.26396
R3167 VSS.n1540 VSS.n1122 3.25296
R3168 VSS.n843 VSS.n839 3.22133
R3169 VSS.n401 VSS.n377 3.14804
R3170 VSS.n777 VSS.n615 3.0813
R3171 VSS.n1543 VSS.n1542 3.0781
R3172 VSS.n1541 VSS.n1119 3.05216
R3173 VSS.n879 VSS.n482 3.04639
R3174 VSS.n1924 VSS 3.02272
R3175 VSS.n1279 VSS 3.02272
R3176 VSS.n1574 VSS 3.02272
R3177 VSS.n1654 VSS 3.02272
R3178 VSS.n238 VSS 3.02272
R3179 VSS.n1436 VSS 3.02272
R3180 VSS.n530 VSS 3.02272
R3181 VSS.n697 VSS 3.02272
R3182 VSS.n81 VSS 3.02272
R3183 VSS.n486 VSS.n482 3.01013
R3184 VSS.t34 VSS.n2 1.01186
R3185 VSS.n1543 VSS.n377 2.9382
R3186 VSS.n1530 VSS.n1122 2.9382
R3187 VSS VSS.n1038 2.90959
R3188 VSS.n919 VSS 2.90959
R3189 VSS VSS.n1013 2.90959
R3190 VSS.n1962 VSS.n1884 2.90959
R3191 VSS.n1958 VSS.n1957 2.90959
R3192 VSS.n1886 VSS.n47 2.90959
R3193 VSS.n1991 VSS.n1990 2.90959
R3194 VSS.n51 VSS.n44 2.90959
R3195 VSS.n1983 VSS.n1982 2.90959
R3196 VSS.n1978 VSS.n52 2.90959
R3197 VSS.n1977 VSS.n54 2.90959
R3198 VSS.n987 VSS.n945 2.89497
R3199 VSS.n987 VSS.n951 2.89497
R3200 VSS.n957 VSS.n951 2.89497
R3201 VSS.n980 VSS.n957 2.89497
R3202 VSS.n980 VSS.n979 2.89497
R3203 VSS.n979 VSS.n978 2.89497
R3204 VSS.n978 VSS.n960 2.89497
R3205 VSS.n962 VSS.n960 2.89497
R3206 VSS.n965 VSS.n962 2.89497
R3207 VSS.n965 VSS.n314 2.89497
R3208 VSS.n1782 VSS.n212 2.89497
R3209 VSS.n1782 VSS.n1781 2.89497
R3210 VSS.n1781 VSS.n1780 2.89497
R3211 VSS.n1780 VSS.n1754 2.89497
R3212 VSS.n1774 VSS.n1754 2.89497
R3213 VSS.n1774 VSS.n1758 2.89497
R3214 VSS.n1760 VSS.n1758 2.89497
R3215 VSS.n1765 VSS.n1760 2.89497
R3216 VSS.n1766 VSS.n1765 2.89497
R3217 VSS.n1766 VSS.n58 2.89497
R3218 VSS.n1055 VSS.n456 2.89497
R3219 VSS.n1055 VSS.n452 2.89497
R3220 VSS.n1061 VSS.n452 2.89497
R3221 VSS.n1062 VSS.n1061 2.89497
R3222 VSS.n1062 VSS.n449 2.89497
R3223 VSS.n449 VSS.n447 2.89497
R3224 VSS.n1069 VSS.n447 2.89497
R3225 VSS.n1069 VSS.n444 2.89497
R3226 VSS.n1075 VSS.n444 2.89497
R3227 VSS.n1076 VSS.n1075 2.89497
R3228 VSS.n1329 VSS.n1328 2.89497
R3229 VSS.n1335 VSS.n1329 2.89497
R3230 VSS.n1338 VSS.n1335 2.89497
R3231 VSS.n1338 VSS.n1324 2.89497
R3232 VSS.n1343 VSS.n1324 2.89497
R3233 VSS.n1346 VSS.n1343 2.89497
R3234 VSS.n1346 VSS.n1322 2.89497
R3235 VSS.n1352 VSS.n1322 2.89497
R3236 VSS.n1352 VSS.n1311 2.89497
R3237 VSS.n1381 VSS.n1311 2.89497
R3238 VSS.n1076 VSS.n441 2.89028
R3239 VSS.n1489 VSS.n313 2.8805
R3240 VSS.n1492 VSS.n1489 2.8805
R3241 VSS.n1495 VSS.n1492 2.8805
R3242 VSS.n1495 VSS.n1485 2.8805
R3243 VSS.n1501 VSS.n1485 2.8805
R3244 VSS.n1504 VSS.n1501 2.8805
R3245 VSS.n1507 VSS.n1504 2.8805
R3246 VSS.n1507 VSS.n1483 2.8805
R3247 VSS.n1513 VSS.n1483 2.8805
R3248 VSS.n1514 VSS.n1513 2.8805
R3249 VSS.n1622 VSS.n314 2.86281
R3250 VSS.n1116 VSS.n1115 2.79785
R3251 VSS.n1480 VSS.n1479 2.72218
R3252 VSS.n1848 VSS.n11 2.70092
R3253 VSS.n1738 VSS.n215 2.66829
R3254 VSS.n2008 VSS.n34 2.6561
R3255 VSS.n2007 VSS.n35 2.6561
R3256 VSS.n1839 VSS.n1837 2.6561
R3257 VSS.n1861 VSS.n1841 2.6561
R3258 VSS.n1860 VSS.n1842 2.6561
R3259 VSS.n1855 VSS.n1854 2.6561
R3260 VSS.n1539 VSS.n1124 2.62831
R3261 VSS.n471 VSS.n469 2.62326
R3262 VSS.n109 VSS.n108 2.61072
R3263 VSS.n1704 VSS.n1701 2.5605
R3264 VSS.n1705 VSS.n276 2.5605
R3265 VSS.n1711 VSS.n1708 2.5605
R3266 VSS.n1712 VSS.n275 2.5605
R3267 VSS.n1718 VSS.n1715 2.5605
R3268 VSS.n1719 VSS.n274 2.5605
R3269 VSS.n1723 VSS.n1722 2.5605
R3270 VSS.n1726 VSS.n273 2.5605
R3271 VSS.n1732 VSS.n1731 2.5605
R3272 VSS.n1729 VSS.n1728 2.5605
R3273 VSS.n1795 VSS.n185 2.53355
R3274 VSS.n1789 VSS.n208 2.47966
R3275 VSS.n441 VSS.n439 2.4726
R3276 VSS.n1621 VSS.n315 2.46298
R3277 VSS.n432 VSS.n277 2.45173
R3278 VSS.n1118 VSS.n379 2.41639
R3279 VSS.n1850 VSS.n1849 2.4004
R3280 VSS.n1958 VSS.n1884 2.32777
R3281 VSS.n1957 VSS.n1886 2.32777
R3282 VSS.n1990 VSS.n47 2.32777
R3283 VSS.n1991 VSS.n41 2.32777
R3284 VSS.n1995 VSS.n44 2.32777
R3285 VSS.n1983 VSS.n51 2.32777
R3286 VSS.n1982 VSS.n52 2.32777
R3287 VSS.n1978 VSS.n1977 2.32777
R3288 VSS.n56 VSS.n54 2.32777
R3289 VSS.n1084 VSS.n439 2.3078
R3290 VSS.n1625 VSS.n309 2.29231
R3291 VSS.n1086 VSS.n1084 2.28033
R3292 VSS.n2001 VSS 2.25633
R3293 VSS.n108 VSS.n34 2.23121
R3294 VSS.n1849 VSS.n1848 2.16084
R3295 VSS.n2015 VSS.n11 2.16084
R3296 VSS.n909 VSS.n908 2.14595
R3297 VSS.n2008 VSS.n2007 2.12498
R3298 VSS.n1837 VSS.n35 2.12498
R3299 VSS.n1840 VSS.n1839 2.12498
R3300 VSS.n1864 VSS.n1841 2.12498
R3301 VSS.n1861 VSS.n1860 2.12498
R3302 VSS.n1855 VSS.n1842 2.12498
R3303 VSS.n1854 VSS.n1851 2.12498
R3304 VSS.n1737 VSS.n212 2.12311
R3305 VSS.n1328 VSS.n1168 2.12311
R3306 VSS.n1623 VSS.n313 2.1125
R3307 VSS.n2015 VSS.n2014 2.05282
R3308 VSS.n2000 VSS.n1997 2.04222
R3309 VSS.n1699 VSS.n278 1.951
R3310 VSS.n992 VSS.n947 1.951
R3311 VSS.n1053 VSS.n457 1.951
R3312 VSS.n1620 VSS.n1619 1.951
R3313 VSS.n1326 VSS.n1161 1.951
R3314 VSS.n903 VSS.n902 1.951
R3315 VSS.n875 VSS.n485 1.951
R3316 VSS.n773 VSS.n618 1.951
R3317 VSS.n1750 VSS.n214 1.951
R3318 VSS.n2014 VSS.n12 1.9448
R3319 VSS.n927 VSS.n459 1.89141
R3320 VSS.n1029 VSS.n1028 1.89141
R3321 VSS.n1865 VSS.n1864 1.80631
R3322 VSS.n1030 VSS.n1029 1.74595
R3323 VSS.n928 VSS.n927 1.74595
R3324 VSS.n845 VSS.n844 1.65389
R3325 VSS.n854 VSS.n853 1.64709
R3326 VSS.n839 VSS.n837 1.6187
R3327 VSS.n1999 VSS.n1998 1.55639
R3328 VSS.n852 VSS.n850 1.54103
R3329 VSS.n1866 VSS.n1865 1.45719
R3330 VSS.n476 VSS.n471 1.4194
R3331 VSS.n1118 VSS.n380 1.39918
R3332 VSS.n1997 VSS.n41 1.39686
R3333 VSS.n852 VSS.n851 1.32907
R3334 VSS.n1799 VSS.n1798 1.32468
R3335 VSS.n725 VSS.n724 1.3077
R3336 VSS.n1477 VSS.n1172 1.24081
R3337 VSS.n1179 VSS.n1178 1.24081
R3338 VSS.n1471 VSS.n1470 1.24081
R3339 VSS.n1208 VSS.n1180 1.24081
R3340 VSS.n1216 VSS.n1211 1.24081
R3341 VSS.n1220 VSS.n1206 1.24081
R3342 VSS.n1410 VSS.n1199 1.24081
R3343 VSS.n1409 VSS.n1197 1.24081
R3344 VSS.n597 VSS.n489 1.21723
R3345 VSS.n594 VSS.n593 1.21723
R3346 VSS.n589 VSS.n561 1.21723
R3347 VSS.n569 VSS.n564 1.21723
R3348 VSS.n583 VSS.n570 1.21723
R3349 VSS.n573 VSS.n428 1.21723
R3350 VSS.n1095 VSS.n1094 1.21723
R3351 VSS.n1100 VSS.n1099 1.21723
R3352 VSS.n1479 VSS.n1478 1.21689
R3353 VSS.n1629 VSS.n1628 1.20153
R3354 VSS.n320 VSS.n318 1.19453
R3355 VSS.n1614 VSS.n321 1.19453
R3356 VSS.n325 VSS.n323 1.19453
R3357 VSS.n1609 VSS.n1608 1.19453
R3358 VSS.n359 VSS.n328 1.19453
R3359 VSS.n363 VSS.n352 1.19453
R3360 VSS.n372 VSS.n371 1.19453
R3361 VSS.n1547 VSS.n349 1.19453
R3362 VSS.n1694 VSS.n283 1.19453
R3363 VSS.n1684 VSS.n286 1.19453
R3364 VSS.n1689 VSS.n1688 1.19453
R3365 VSS.n807 VSS.n787 1.19453
R3366 VSS.n827 VSS.n795 1.19453
R3367 VSS.n815 VSS.n802 1.19453
R3368 VSS.n822 VSS.n821 1.19453
R3369 VSS.n1829 VSS.n158 1.1912
R3370 VSS.n161 VSS.n159 1.1912
R3371 VSS.n1822 VSS.n1821 1.1912
R3372 VSS.n1816 VSS.n1815 1.1912
R3373 VSS.n178 VSS.n173 1.1912
R3374 VSS.n1808 VSS.n176 1.1912
R3375 VSS.n1804 VSS.n1803 1.1912
R3376 VSS.n1539 VSS.n1125 1.18726
R3377 VSS.n1745 VSS.n1744 1.163
R3378 VSS.n1600 VSS.n315 1.15277
R3379 VSS.n908 VSS.n907 1.12777
R3380 VSS.n624 VSS.n620 1.11989
R3381 VSS.n761 VSS.n760 1.11989
R3382 VSS.n648 VSS.n647 1.11989
R3383 VSS.n655 VSS.n652 1.11989
R3384 VSS.n744 VSS.n653 1.11989
R3385 VSS.n664 VSS.n659 1.11989
R3386 VSS.n670 VSS.n667 1.11989
R3387 VSS.n730 VSS.n668 1.11989
R3388 VSS.n1997 VSS.n1996 1.10595
R3389 VSS VSS.n579 1.07122
R3390 VSS.n1836 VSS.n1835 1.06815
R3391 VSS.n2002 VSS.n2001 1.06717
R3392 VSS.n836 VSS.n835 1.06574
R3393 VSS.n1744 VSS.n1743 1.04236
R3394 VSS.n1478 VSS.n1477 1.04236
R3395 VSS.n754 VSS.n753 1.02255
R3396 VSS.n1600 VSS.n318 1.00349
R3397 VSS VSS.n794 1.00349
R3398 VSS.n1829 VSS.n1828 0.992748
R3399 VSS.n162 VSS.n161 0.992748
R3400 VSS.n1823 VSS.n1822 0.992748
R3401 VSS.n1834 VSS.n137 0.992748
R3402 VSS.n1815 VSS.n1814 0.992748
R3403 VSS.n171 VSS.n170 0.992748
R3404 VSS.n1809 VSS.n173 0.992748
R3405 VSS.n181 VSS.n176 0.992748
R3406 VSS.n1803 VSS.n182 0.992748
R3407 VSS.n1178 VSS.n1172 0.992748
R3408 VSS.n1471 VSS.n1179 0.992748
R3409 VSS.n1470 VSS.n1180 0.992748
R3410 VSS.n1211 VSS.n1208 0.992748
R3411 VSS.n1217 VSS.n1216 0.992748
R3412 VSS VSS.n1205 0.992748
R3413 VSS.n1220 VSS.n1205 0.992748
R3414 VSS.n1206 VSS.n1199 0.992748
R3415 VSS.n1410 VSS.n1409 0.992748
R3416 VSS.n1224 VSS.n1197 0.992748
R3417 VSS.n624 VSS.n622 0.973884
R3418 VSS.n760 VSS.n623 0.973884
R3419 VSS.n649 VSS.n648 0.973884
R3420 VSS.n745 VSS.n652 0.973884
R3421 VSS.n658 VSS.n653 0.973884
R3422 VSS.n739 VSS.n736 0.973884
R3423 VSS.n664 VSS.n661 0.973884
R3424 VSS.n731 VSS.n667 0.973884
R3425 VSS.n672 VSS.n668 0.973884
R3426 VSS.n1614 VSS.n320 0.955724
R3427 VSS.n323 VSS.n321 0.955724
R3428 VSS.n1609 VSS.n325 0.955724
R3429 VSS.n1608 VSS.n328 0.955724
R3430 VSS.n360 VSS.n359 0.955724
R3431 VSS VSS.n357 0.955724
R3432 VSS.n363 VSS.n357 0.955724
R3433 VSS.n372 VSS.n352 0.955724
R3434 VSS.n371 VSS.n349 0.955724
R3435 VSS.n1547 VSS.n1546 0.955724
R3436 VSS.n1695 VSS.n282 0.955724
R3437 VSS.n170 VSS 0.943136
R3438 VSS.n1224 VSS.n1121 0.943136
R3439 VSS.n1514 VSS.n189 0.9285
R3440 VSS.n1727 VSS.n209 0.9285
R3441 VSS.n598 VSS.n488 0.925215
R3442 VSS.n437 VSS.n436 0.925215
R3443 VSS.n1546 VSS.n348 0.907963
R3444 VSS.n285 VSS.n283 0.907963
R3445 VSS.n1684 VSS.n289 0.907963
R3446 VSS.n1688 VSS.n290 0.907963
R3447 VSS.n834 VSS.n833 0.907963
R3448 VSS.n807 VSS.n792 0.907963
R3449 VSS.n828 VSS.n794 0.907963
R3450 VSS.n801 VSS.n795 0.907963
R3451 VSS.n816 VSS.n815 0.907963
R3452 VSS.n821 VSS.n820 0.907963
R3453 VSS.n1629 VSS.n308 0.907963
R3454 VSS.n1799 VSS.n184 0.893523
R3455 VSS.n1540 VSS.n1121 0.893523
R3456 VSS.n488 VSS.n486 0.876546
R3457 VSS.n490 VSS.n489 0.876546
R3458 VSS.n593 VSS.n491 0.876546
R3459 VSS.n589 VSS.n588 0.876546
R3460 VSS.n584 VSS.n569 0.876546
R3461 VSS.n571 VSS.n570 0.876546
R3462 VSS.n579 VSS.n574 0.876546
R3463 VSS.n1093 VSS.n428 0.876546
R3464 VSS.n1095 VSS.n424 0.876546
R3465 VSS.n1099 VSS.n425 0.876546
R3466 VSS.n1086 VSS.n437 0.876546
R3467 VSS.n754 VSS.n619 0.876546
R3468 VSS VSS.n739 0.876546
R3469 VSS.n1542 VSS.n348 0.860201
R3470 VSS.n1085 VSS.n282 0.860201
R3471 VSS.n1865 VSS.n1840 0.850293
R3472 VSS.n772 VSS.n766 0.844053
R3473 VSS.n874 VSS.n602 0.834494
R3474 VSS.n726 VSS.n725 0.827876
R3475 VSS.n835 VSS.n834 0.81244
R3476 VSS.n1147 VSS.n378 0.804872
R3477 VSS.n1402 VSS.n1123 0.804872
R3478 VSS.n1541 VSS.n1120 0.763414
R3479 VSS.n1835 VSS.n1834 0.670267
R3480 VSS.n837 VSS.n477 0.664786
R3481 VSS.n887 VSS.n477 0.620569
R3482 VSS.n1835 VSS.n136 0.52143
R3483 VSS.n889 VSS.n476 0.487697
R3484 VSS.n1377 VSS.n1310 0.468015
R3485 VSS.n1999 VSS 0.4655
R3486 VSS.n836 VSS.n135 0.414974
R3487 VSS.n1996 VSS.n1995 0.407773
R3488 VSS.n1866 VSS.n1836 0.405105
R3489 VSS.n1537 VSS.n12 0.404263
R3490 VSS.n1836 VSS.n135 0.401816
R3491 VSS.n835 VSS.n786 0.38259
R3492 VSS.n1383 VSS.n1382 0.381957
R3493 VSS.n1039 VSS 0.364136
R3494 VSS VSS.n918 0.364136
R3495 VSS.n1014 VSS 0.364136
R3496 VSS VSS.n4 0.362337
R3497 VSS.n433 VSS.n279 0.357582
R3498 VSS.n1701 VSS.n277 0.3205
R3499 VSS.n1705 VSS.n1704 0.3205
R3500 VSS.n1708 VSS.n276 0.3205
R3501 VSS.n1712 VSS.n1711 0.3205
R3502 VSS.n1715 VSS.n275 0.3205
R3503 VSS.n1719 VSS.n1718 0.3205
R3504 VSS.n1722 VSS.n274 0.3205
R3505 VSS.n1723 VSS.n273 0.3205
R3506 VSS.n1732 VSS.n1726 0.3205
R3507 VSS.n1731 VSS.n1729 0.3205
R3508 VSS.n1728 VSS.n1727 0.3205
R3509 VSS.n1970 VSS.n58 0.289947
R3510 VSS.n1382 VSS.n1381 0.289947
R3511 VSS.n433 VSS.n432 0.275178
R3512 VSS.n1851 VSS.n1850 0.26606
R3513 VSS.n1867 VSS.n1866 0.258833
R3514 VSS VSS.n167 0.248562
R3515 VSS.n1217 VSS 0.248562
R3516 VSS.n608 VSS.n135 0.245237
R3517 VSS.n740 VSS 0.243846
R3518 VSS.n360 VSS 0.239306
R3519 VSS.n1377 VSS.n12 0.191756
R3520 VSS.n798 VSS 0.191545
R3521 VSS.n1868 VSS.n1867 0.177663
R3522 VSS.n580 VSS 0.146508
R3523 VSS.n837 VSS.n836 0.141947
R3524 VSS.n1086 VSS.n1085 0.137839
R3525 VSS.n724 VSS.n208 0.108289
R3526 VSS.n1789 VSS.n1788 0.108289
R3527 VSS.n1382 VSS.n1310 0.106753
R3528 VSS.n598 VSS.n597 0.0978384
R3529 VSS.n594 VSS.n490 0.0978384
R3530 VSS.n561 VSS.n491 0.0978384
R3531 VSS.n588 VSS.n564 0.0978384
R3532 VSS.n584 VSS.n583 0.0978384
R3533 VSS.n580 VSS.n571 0.0978384
R3534 VSS.n574 VSS.n573 0.0978384
R3535 VSS.n1094 VSS.n1093 0.0978384
R3536 VSS.n1100 VSS.n424 0.0978384
R3537 VSS.n436 VSS.n425 0.0978384
R3538 VSS.n753 VSS.n620 0.0978384
R3539 VSS.n761 VSS.n622 0.0978384
R3540 VSS.n647 VSS.n623 0.0978384
R3541 VSS.n655 VSS.n649 0.0978384
R3542 VSS.n745 VSS.n744 0.0978384
R3543 VSS.n740 VSS.n658 0.0978384
R3544 VSS.n736 VSS.n659 0.0978384
R3545 VSS.n670 VSS.n661 0.0978384
R3546 VSS.n731 VSS.n730 0.0978384
R3547 VSS.n726 VSS.n672 0.0978384
R3548 VSS.n1737 VSS.n209 0.0813421
R3549 VSS.n1739 VSS.n1738 0.0543947
R3550 VSS.n1745 VSS.n215 0.0543947
R3551 VSS.n1798 VSS.n185 0.0543947
R3552 VSS.n1795 VSS.n1794 0.0543947
R3553 VSS.n1743 VSS.n158 0.0501124
R3554 VSS.n1828 VSS.n159 0.0501124
R3555 VSS.n1821 VSS.n162 0.0501124
R3556 VSS.n1823 VSS.n136 0.0501124
R3557 VSS.n1816 VSS.n137 0.0501124
R3558 VSS.n1814 VSS.n167 0.0501124
R3559 VSS.n178 VSS.n171 0.0501124
R3560 VSS.n1809 VSS.n1808 0.0501124
R3561 VSS.n1804 VSS.n181 0.0501124
R3562 VSS.n184 VSS.n182 0.0501124
R3563 VSS.n1628 VSS.n309 0.0492619
R3564 VSS.n1625 VSS.n1624 0.0492619
R3565 VSS.n1695 VSS.n1694 0.0482612
R3566 VSS.n286 VSS.n285 0.0482612
R3567 VSS.n1689 VSS.n289 0.0482612
R3568 VSS.n786 VSS.n290 0.0482612
R3569 VSS.n833 VSS.n787 0.0482612
R3570 VSS.n798 VSS.n792 0.0482612
R3571 VSS.n828 VSS.n827 0.0482612
R3572 VSS.n802 VSS.n801 0.0482612
R3573 VSS.n822 VSS.n816 0.0482612
R3574 VSS.n820 VSS.n308 0.0482612
R3575 VSS.n839 VSS.n838 0.0465396
R3576 VSS.n866 VSS.n608 0.0454123
R3577 VSS.n1168 VSS.n189 0.0274474
R3578 VSS.n1623 VSS.n1622 0.024881
R3579 VSS.n853 VSS 0.0232273
R3580 VSS.n845 VSS 0.0188824
R3581 VSS.n1999 VSS 0.0169474
C0 MSU1.S M1.G0 0.17583f
C1 ME1.S M1.G0 0.47885f
C2 RPTAT_lay_0.B Q1.Emitter 1.72792f
C3 M1.S1 Q1.Emitter 5.41545f
C4 M1.S1 inv_0.Y 0.1038f
C5 RPTAT_lay_0.B RCTAT_lay_0.A 0.78638f
C6 VIN MSU1.S 0.89905f
C7 VIN ME1.S 1.89267f
C8 MSU1.S ME1.S 0.43839f
C9 RCTAT_lay_0.R3.R1 RCTAT_lay_0.A 0.54552f
C10 M1.S1 RCTAT_lay_0.A 4.23719f
C11 M1.G0 RCTAT_lay_0.A 2.26006f
C12 RL_lay_0.R3.R1 VREF 0.5484f
C13 M1.S1 EN 1.08549f
C14 VIN inv_0.Y 0.62637f
C15 EN M1.G0 0.26712f
C16 RCTAT_lay_0.R4.R2 RCTAT_lay_0.R2.R2 0.45776f
C17 VREF M1.G0 4.35056f
C18 M1.S1 RPTAT_lay_0.B 0.20207f
C19 VIN EN 1.85733f
C20 MSU1.S EN 0.10653f
C21 ME1.S EN 0.85796f
C22 M1.S1 M1.G0 9.01559f
C23 Q1.Emitter RCTAT_lay_0.A 0.36175f
C24 VREF VIN 2.94988f
C25 RL_lay_0.R4.R2 RL_lay_0.R2.R2 0.45873f
C26 inv_0.Y EN 0.49479f
C27 M1.S1 VIN 3.14029f
C28 M1.S1 ME2.S 0.11748f
C29 VIN M1.G0 33.1137f
C30 M1.S1 MSU1.S 0.29639f
C31 RCTAT_lay_0.R3.R1 RCTAT_lay_0.R5.R1 0.45854f
C32 RCTAT_lay_0.R4.R2 RCTAT_lay_0.R6.R1 0.45776f
C33 EN VSS 4.83055f
C34 VREF VSS 2.80856f
C35 VIN VSS 63.55453f
C36 RCTAT_lay_0.R6.R1 VSS 0.55226f
C37 RCTAT_lay_0.R5.R1 VSS 0.76022f
C38 RCTAT_lay_0.R4.R2 VSS 0.31668f
C39 RCTAT_lay_0.R3.R1 VSS 0.30761f
C40 RCTAT_lay_0.R2.R2 VSS 0.53686f
C41 RL_lay_0.R4.R2 VSS 0.56184f
C42 RL_lay_0.R3.R1 VSS 0.72696f
C43 RL_lay_0.R2.R2 VSS 0.54122f
C44 RPTAT_lay_0.B VSS 15.3292f
C45 ME2.S VSS 0.26316f
C46 MSU1.S VSS 0.29883f
C47 ME1.S VSS 0.36871f
C48 inv_0.Y VSS 0.88621f
C49 RCTAT_lay_0.A VSS 9.28492f
C50 Q1.Emitter VSS 5.93232f
C51 M1.S1 VSS 18.1001f
C52 M1.G0 VSS 3.66166f
C53 VIN.n3 VSS 0.99057f
C54 VIN.n4 VSS 0.55757f
C55 VIN.n5 VSS 0.35306f
C56 VIN.n6 VSS 0.42173f
C57 VIN.n7 VSS 0.42924f
C58 VIN.n8 VSS 0.31533f
C59 VIN.n16 VSS 0.1433f
C60 VIN.t37 VSS 1.41075f
C61 VIN.t35 VSS 1.07786f
C62 VIN.t1 VSS 0.84705f
C63 VIN.t33 VSS 0.88438f
C64 VIN.t0 VSS 0.84704f
C65 VIN.t31 VSS 0.78654f
C66 VIN.t43 VSS 0.84705f
C67 VIN.t29 VSS 0.60903f
C68 VIN.t41 VSS 0.6734f
C69 VIN.t39 VSS 0.70802f
C70 VIN.t27 VSS -0.11266f
C71 VIN.t3 VSS 1.45649f
C72 VIN.t5 VSS 1.16166f
C73 VIN.t7 VSS 1.16166f
C74 VIN.t9 VSS 1.16166f
C75 VIN.t11 VSS 1.16166f
C76 VIN.t13 VSS 1.39294f
C77 VIN.t15 VSS 1.39294f
C78 VIN.t17 VSS 1.16166f
C79 VIN.t19 VSS 1.16166f
C80 VIN.t21 VSS 1.16166f
C81 VIN.t23 VSS 1.16166f
C82 VIN.t25 VSS 1.26278f
C83 VIN.n27 VSS 1.23621f
C84 VIN.n28 VSS 0.10964f
C85 VIN.n30 VSS 0.27892f
C86 VIN.n31 VSS 2.08459f
C87 VIN.n32 VSS 3.28809f
C88 VIN.n36 VSS 0.83579f
C89 VIN.n37 VSS 0.55826f
C90 VIN.n38 VSS 0.42689f
C91 VIN.n39 VSS 0.35318f
C92 VIN.n40 VSS 0.42799f
C93 VIN.n41 VSS 3.96306f
C94 VREF.n0 VSS 0.19427f
C95 VREF.n1 VSS 0.29522f
C96 VREF.n2 VSS 0.20415f
C97 VREF.n3 VSS 0.89455f
C98 VREF.n4 VSS 0.19427f
C99 VREF.n5 VSS 1.50858f
C100 VREF.n6 VSS 0.19427f
C101 VREF.n7 VSS 1.73376f
C102 EN.t2 VSS 0.31349f
C103 EN.t4 VSS 0.22337f
C104 EN.n0 VSS 0.17501f
C105 EN.n1 VSS 1.22557f
C106 EN.t3 VSS 0.31349f
C107 EN.n2 VSS 0.59897f
C108 EN.n3 VSS 0.35862f
.ends
